* Closed-loop follower testbench for transient / THD.
* The amp is wired as a real unity-gain follower (inn = out), driven with a
* 1 kHz sine centered at mid-supply (NOT at {vincm}: THD must be measured on
* the same large swing at every corner). Amplitude vamp=1.3 V sweeps
* 0.35..2.95 V at vdd=3.3 - about 80% of the supply, exercising both input
* pairs and the constant-gm crossover.
V2 vdd GND {vdd}
Vc netc GND {vdd*0.5}
V4 vdin GND dc 0 sin(0 {vamp} 1e3)
E1 inp netc vdin GND 1

* Single reference current into the ibias pin (see opamp_rtr.spice)
Ib vdd nib {i_ref}

* mid-supply node: return for the application load only
Vmid nmid GND {vdd*0.5}

* inn tied directly to out (same node) = unity-gain follower
x1 vdd GND nib inp out out opamp

* application load: diff-amp feedback network (~10k) to mid-supply + parasitics
RL out nmid 10e3
.param cl=5e-12
.param vamp=1.3
CL out GND {cl}

.GLOBAL GND
.end
