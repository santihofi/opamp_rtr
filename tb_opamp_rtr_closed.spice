* Closed-loop follower testbench for transient / THD.
* The amp is wired as a real unity-gain follower (inn = out), driven with a
* 1 kHz sine centered at mid-supply (NOT at {vincm}: THD must be measured on
* the same large swing at every corner). Amplitude vamp=1.3 V sweeps
* 0.35..2.95 V at vdd=3.3 - about 80% of the supply, exercising both input
* pairs and the constant-gm crossover.
V2 vdd GND {vdd}
Vc netc GND {vdd*0.5}
V4 vdin GND dc 0 sin(0 {vamp} 1e3)
E1 inp netc vdin GND 1

* Single reference current into the ibias pin (see opamp_rtr.spice)
Ib vdd nib {i_ref}

* mid-supply node: return for the application load only
Vmid nmid GND {vdd*0.5}

* inn tied directly to out (same node) = unity-gain follower
x1 vdd GND nib inp out out opamp

* Application load = the diff-amp feedback network, returned to mid-supply.
* 100k not 10k: at vincm=3.1, vdd=3.2 a 10k return draws (3.1-1.6)/10k = 150 uA
* from the output PMOS while it sits 100 mV from the rail, which pushes it into
* triode (needs |Vdss|=0.24 V) and costs 65 dB of open-loop gain. See notes.
.param rl=100e3
RL out nmid {rl}
.param cl=5e-12
.param vamp=1.3
CL out GND {cl}

.GLOBAL GND
.end
