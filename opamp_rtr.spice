*=======================================================================================

* opamp_rtr.spice
* created by Santiago Hofwimmer
* JKU IICQC
*
* A simple Rail-to-Rail opamp in the IHP-sg13CMOS5l PDK
* Two-stage: complementary input pairs, Monticelli class-AB output stage
* 3.3 V supply, thick-oxide HV devices (sg13_hv_*, min L 0.45u, min W 0.3u)
*
* NOTE: all {w_*}/{l_*}/{c_*}/{r_*} parameters are injected by PyOPUS as .param
* lines. Do NOT .include opamp_rtr_params.spice here: PyOPUS writes its .param
* BEFORE the module includes and ngspice takes the last definition, so an
* include here would silently override the optimizer. opamp_rtr_params.spice
* records seed/frozen values for standalone simulation only.
*=======================================================================================

* CURRENT-MODE BIASING. The block takes ONE external reference current into
* the ibias pin (bandgap + resistor, or a beta-multiplier) and generates all
* four internal gate-bias rails locally. No bias voltages are distributed:
* each rail is a diode-connected replica of the devices it drives, so it
* tracks its own rail and its own device family across process/temperature.
* ibias is both the current input and the NMOS gate-bias rail (XB1 is
* diode-connected on it), which is why the NMOS sources gate from 'ibias'.
* No startup circuit is needed - the reference current is supplied externally.

*.include opamp_rtr_params.spice

.subckt opamp vdd vss ibias inp inn out

*=======================================================================================

* Bias generator
*
*   ibias  -> XB1 NMOS master diode          -> NMOS gate rail (= ibias node)
*   XB2/XB3 mirror I_ref up to a PMOS diode  -> vbias_p (vdd-referenced)
*   XB4/XB5 set the low  constant-gm switch reference -> vref_n
*   XB6/XB7 set the high constant-gm switch reference -> vref_p
*
* Branch currents are all I_ref. The W ratio to each biased device sets that
* device's current (all share l_bias, so it is a clean width ratio).

XB1 ibias ibias vss vss sg13_hv_nmos w={w_bias_n} l={l_bias} ng=1 m=1 mm_ok=1
XB2 vbias_p ibias vss vss sg13_hv_nmos w={w_bias_n} l={l_bias} ng=1 m=1 mm_ok=1
XB3 vbias_p vbias_p vdd vdd sg13_hv_pmos w={w_bias_p} l={l_bias} ng=1 m=1 mm_ok=1

XB4 vref_n vbias_p vdd vdd sg13_hv_pmos w={w_bias_p} l={l_bias} ng=1 m=1 mm_ok=1
XB5 vref_n vref_n vss vss sg13_hv_nmos w={w_ref_n} l={l_bias} ng=1 m=1 mm_ok=1

XB6 vref_p ibias vss vss sg13_hv_nmos w={w_bias_n} l={l_bias} ng=1 m=1 mm_ok=1
XB7 vref_p vref_p vdd vdd sg13_hv_pmos w={w_ref_p} l={l_bias} ng=1 m=1 mm_ok=1

*=======================================================================================

* PMOS input stage

*Differential pair (PMOS)

XM1 out1_p inp ncmdiff_p vdd sg13_hv_pmos w={w_diff_p} l={l_diff_p} ng=1 m=1 mm_ok=1
XM2 n1 inn ncmdiff_p vdd sg13_hv_pmos w={w_diff_p} l={l_diff_p} ng=1 m=1 mm_ok=1

* Tail current source (PMOS)

XM3 ncmdiff_p vbias_p vdd vdd sg13_hv_pmos w={w_tail_p} l={l_bias} ng=1 m=1 mm_ok=1

* Load Current Mirror (NMOS)

XM4 out1_p n1 vss vss sg13_hv_nmos w={w_load_n} l={l_load_n} ng=1 m=1 mm_ok=1
XM5 n1 n1 vss vss sg13_hv_nmos w={w_load_n} l={l_load_n} ng=1 m=1 mm_ok=1

*=======================================================================================

* NMOS input stage

* Differential pair (NMOS)

XM6 out1_n inp ncmdiff_n vss sg13_hv_nmos w={w_diff_n} l={l_diff_n} ng=1 m=1 mm_ok=1
XM7 n2 inn ncmdiff_n vss sg13_hv_nmos w={w_diff_n} l={l_diff_n} ng=1 m=1 mm_ok=1

* Tail current source (NMOS)

XM8 ncmdiff_n ibias vss vss sg13_hv_nmos w={w_tail_n} l={l_bias} ng=1 m=1 mm_ok=1

* Load Current Mirror (PMOS)

XM9 out1_n n2 vdd vdd sg13_hv_pmos w={w_load_p} l={l_load_p} ng=1 m=1 mm_ok=1
XM10 n2 n2 vdd vdd sg13_hv_pmos w={w_load_p} l={l_load_p} ng=1 m=1 mm_ok=1

*=======================================================================================

* Constant-gm input biasing (tail-current switches, referenced to the rails)
*
* XM25 conducts only once vincm > vref_p - Vov, i.e. when the PMOS pair is
* running out of headroom near the top rail. It diverts the PMOS tail current
* and mirrors it (XM26/XM27, ratio w_gmn2/w_gmn1) into the NMOS tail node, so
* the NMOS pair gains exactly what the PMOS pair lost. XM28/XM29/XM30 do the
* mirror image near the bottom rail. Both switches must be OFF in mid-range or
* they starve both pairs at once (gain collapse). Keeps total input gm - and
* thus follower loop gain - flat across the range, which is what suppresses
* input-stage distortion for audio.

XM25 nswa vref_p ncmdiff_p vdd sg13_hv_pmos w={w_sw_p} l=1e-6 ng=1 m=1 mm_ok=1
XM26 nswa nswa vss vss sg13_hv_nmos w={w_gmn} l={l_bias} ng=1 m=1 mm_ok=1
XM27 ncmdiff_n nswa vss vss sg13_hv_nmos w={w_gmn} l={l_bias} ng=1 m=1 mm_ok=1

XM28 nswb vref_n ncmdiff_n vss sg13_hv_nmos w={w_sw_n} l=1e-6 ng=1 m=1 mm_ok=1
XM29 nswb nswb vdd vdd sg13_hv_pmos w={w_gmp} l={l_bias} ng=1 m=1 mm_ok=1
XM30 ncmdiff_p nswb vdd vdd sg13_hv_pmos w={w_gmp} l={l_bias} ng=1 m=1 mm_ok=1

*=======================================================================================

* Class-AB quiescent-current control (Monticelli floating current source)
*
* Floating pair sits between out1_n (high node, gate of XM11) and out1_p (low
* node, gate of XM12). XM15 pushes I_ab into out1_n, XM16 pulls I_ab out of
* out1_p, so both first-stage mirrors stay balanced and I_ab flows through the
* floating pair from out1_n to out1_p.
*
* Translinear loop, NMOS side:  Vgs(XM19)+Vgs(XM18) = Vgs(XM13)+Vgs(XM12)
* Translinear loop, PMOS side:  Vsg(XM22)+Vsg(XM21) = Vsg(XM14)+Vsg(XM11)

* Floating pair

XM13 out1_n nab_n out1_p vss sg13_hv_nmos w={w_ab_n} l={l_ab_n} ng=1 m=1 mm_ok=1
XM14 out1_p nab_p out1_n vdd sg13_hv_pmos w={w_ab_p} l={l_ab_p} ng=1 m=1 mm_ok=1

* I_ab feed: PMOS source into out1_n, NMOS sink out of out1_p.
* The sink gate is NOT vbias_n: XM23/XM24 derive it by mirroring the PMOS
* source current, so I(XM16)=I(XM15) tracks across process/temperature.
* (With independent P/N biases the mismatch current had to be absorbed by the
* high-impedance out1_n/out1_p nodes, railing the output stage.)

XM15 out1_n vbias_p vdd vdd sg13_hv_pmos w={w_ab_src} l={l_bias} ng=1 m=1 mm_ok=1
XM16 out1_p nab_ref vss vss sg13_hv_nmos w={w_ab_snk} l={l_bias} ng=1 m=1 mm_ok=1

* I_ab tracking reference (PMOS copy of XM15 into diode NMOS)

XM23 nab_ref vbias_p vdd vdd sg13_hv_pmos w={w_ab_src} l={l_bias} ng=1 m=1 mm_ok=1
XM24 nab_ref nab_ref vss vss sg13_hv_nmos w={w_ab_snk} l={l_bias} ng=1 m=1 mm_ok=1

* Translinear bias stack, NMOS side (PMOS feed + two diode-connected NMOS)

XM17 nab_n vbias_p vdd vdd sg13_hv_pmos w={w_ab_src} l={l_bias} ng=1 m=1 mm_ok=1
XM18 nab_n nab_n nstack_n vss sg13_hv_nmos w={w_ab_n} l={l_ab_n} ng=1 m=1 mm_ok=1
XM19 nstack_n nstack_n vss vss sg13_hv_nmos w={w_ab_n} l={l_ab_n} ng=1 m=1 mm_ok=1

* Translinear bias stack, PMOS side (NMOS sink + two diode-connected PMOS)

XM20 nab_p nab_ref vss vss sg13_hv_nmos w={w_ab_snk} l={l_bias} ng=1 m=1 mm_ok=1
XM21 nab_p nab_p nstack_p vdd sg13_hv_pmos w={w_ab_p} l={l_ab_p} ng=1 m=1 mm_ok=1
XM22 nstack_p nstack_p vdd vdd sg13_hv_pmos w={w_ab_p} l={l_ab_p} ng=1 m=1 mm_ok=1

*=======================================================================================

* second stage
* class AB output stage

XM11 out out1_n vdd vdd sg13_hv_pmos w={w_out_p} l={l_out_p} ng=1 m=1 mm_ok=1
XM12 out out1_p vss vss sg13_hv_nmos w={w_out_n} l={l_out_n} ng=1 m=1 mm_ok=1

* Miller compensation, one branch per signal path, each with a nulling resistor.
*
* A bare Miller cap feeds the output forward as well as back, which puts a
* right-half-plane zero at gm_out/Cc. That zero adds gain while subtracting
* phase, right where the loop crosses unity, so the only way to keep phase
* margin is to grow Cc until the crossover sits well below it. That is what
* costs bandwidth and settling time.
*
* Rz cancels the feedforward: the zero moves to 1/(Cc*(1/gm_out - Rz)). At
* Rz = 1/gm_out it is at infinity, and above that it folds into the left half
* plane where it can be placed on the first non-dominant pole and cancel it.
* This gives the optimizer a way to buy phase margin without buying it with a
* bigger Cc. Seeded at 1 kohm, which is small against 1/gm_out and so starts
* the search from the plain-Miller behaviour.
*
* Ideal R here, matching the ideal Cc above. On silicon these become poly
* resistors or triode MOS devices, and a triode MOS tracks 1/gm_out over
* process and temperature, which a poly resistor does not.

Rz1 out nz_p {r_null_p}
Cc1 nz_p out1_n {c_miller_p}

Rz2 out nz_n {r_null_n}
Cc2 nz_n out1_p {c_miller_n}

*=======================================================================================

.ends
