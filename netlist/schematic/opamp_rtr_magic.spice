** sch_path: /foss/designs/heichip/opamp_rtr/schematic/xschem/opamp_rtr.sch
.subckt opamp_rtr vdd inp vss inn ibias out
*.PININFO inp:I out:O vdd:B inn:I ibias:I vss:B
XXM6 out1_n inp ncmdiff_n vss sg13_hv_nmos w=5u l=2u ng=4 m=1 mm_ok=1
XXM1 net1 inn ncmdiff_p ncmdiff_p sg13_hv_pmos w=15u l=2u ng=4 m=1 mm_ok=1
XXM2 ncmdiff_p inp out1_p ncmdiff_p sg13_hv_pmos w=15u l=2u ng=4 m=1 mm_ok=1
XXM3 ncmdiff_p vbias_p vdd vdd sg13_hv_pmos w=15u l=4u ng=2 m=1 mm_ok=1
XXM4 vss net1 net1 vss sg13_hv_nmos w=5u l=4u ng=4 m=1 mm_ok=1
XXM5 out1_p net1 vss vss sg13_hv_nmos w=5u l=4u ng=4 m=1 mm_ok=1
XXM7 ncmdiff_n inn net2 vss sg13_hv_nmos w=5u l=2u ng=4 m=1 mm_ok=1
XXM8 ncmdiff_n ibias vss vss sg13_hv_nmos w=5u l=4u ng=2 m=1 mm_ok=1
XXM9 vdd net2 out1_n vdd sg13_hv_pmos w=15u l=4u ng=4 m=1 mm_ok=1
XXM10 net2 net2 vdd vdd sg13_hv_pmos w=15u l=4u ng=4 m=1 mm_ok=1
XXM25 nswa vbias_p ncmdiff_p ncmdiff_p sg13_hv_pmos w=15u l=1u ng=2 m=1 mm_ok=1
XXM26 nswa nswa vss vss sg13_hv_nmos w=5u l=4u ng=4 m=1 mm_ok=1
XXM27 ncmdiff_n nswa vss vss sg13_hv_nmos w=5u l=4u ng=4 m=1 mm_ok=1
XXM28 ncmdiff_n vbias_p nswb vss sg13_hv_nmos w=5u l=1u ng=2 m=1 mm_ok=1
XXM29 nswb nswb vdd vdd sg13_hv_pmos w=15u l=4u ng=4 m=1 mm_ok=1
XXM30 ncmdiff_p nswb vdd vdd sg13_hv_pmos w=15u l=4u ng=4 m=1 mm_ok=1
XXM13 out1_n nabn out1_p vss sg13_hv_nmos w=5u l=1u ng=2 m=1 mm_ok=1
XXM14 out1_p nabp out1_n vdd sg13_hv_pmos w=15u l=1u ng=2 m=1 mm_ok=1
XXM15 out1_n vbias_p vdd vdd sg13_hv_pmos w=15u l=4u ng=2 m=1 mm_ok=1
XXM16 out1_p nab_ref vss vss sg13_hv_nmos w=5u l=4u ng=2 m=1 mm_ok=1
XXM23 nab_ref vbias_p vdd vdd sg13_hv_pmos w=15u l=4u ng=2 m=1 mm_ok=1
XXM24 nab_ref nab_ref vss vss sg13_hv_nmos w=5u l=4u ng=2 m=1 mm_ok=1
XXM17 nabn vbias_p vdd vdd sg13_hv_pmos w=15u l=4u ng=2 m=1 mm_ok=1
XXM18 nabn nabn net3 vss sg13_hv_nmos w=5u l=1u ng=2 m=1 mm_ok=1
XXM19 net3 net3 vss vss sg13_hv_nmos w=5u l=1u ng=2 m=1 mm_ok=1
XXM20 nabp nab_ref vss vss sg13_hv_nmos w=5u l=4u ng=2 m=1 mm_ok=1
XXM21 nabp nabp net4 vdd sg13_hv_pmos w=15u l=1u ng=2 m=1 mm_ok=1
XXM22 net4 net4 vdd vdd sg13_hv_pmos w=15u l=1u ng=2 m=1 mm_ok=1
XXM11 out out1_n vdd vdd sg13_hv_pmos w=60u l=1u ng=8 m=1 mm_ok=1
XXM12 out out1_p vss vss sg13_hv_nmos w=20u l=1u ng=8 m=1 mm_ok=1
XXB1 ibias ibias vss vss sg13_hv_nmos w=5u l=4u ng=2 m=1 mm_ok=1
XXB2 vbias_p ibias vss vss sg13_hv_nmos w=5u l=4u ng=2 m=1 mm_ok=1
XXB3 vbias_p vbias_p vdd vdd sg13_hv_pmos w=15u l=4u ng=2 m=1 mm_ok=1
XC3 out net5 cap_cmomf w=13.5e-6 l=21e-6 mmin=1 mmax=4 subblock=0 m=1 mm_ok=1
XC2 out net6 cap_cmomf w=13.5e-6 l=21e-6 mmin=1 mmax=4 subblock=0 m=1 mm_ok=1
XR4 net5 out1_n vss rhigh w=1e-6 l=36e-6 m=1 b=0 mm_ok=1
XR2 net6 out1_p vss rhigh w=1e-6 l=36e-6 m=1 b=0 mm_ok=1
XDUMMY1 ncmdiff_n ncmdiff_n ncmdiff_n vss sg13_hv_nmos w=5u l=0.45u ng=4 m=1 mm_ok=1
XDUMMY2 ncmdiff_n ncmdiff_n ncmdiff_n vss sg13_hv_nmos w=5u l=0.45u ng=2 m=1 mm_ok=1
XDUMMY10 out1_n out1_n out1_n vdd sg13_hv_pmos w=15u l=1u ng=2 m=1 mm_ok=1
XDUMMY11 out1_p out1_p out1_p vss sg13_hv_nmos w=5u l=1u ng=2 m=1 mm_ok=1
XRDUMMY vss vss vss rhigh w=1e-6 l=9e-6 m=2 b=0 mm_ok=1
XDUMMY3 ncmdiff_p ncmdiff_p ncmdiff_p ncmdiff_p sg13_hv_pmos w=15u l=0.4u ng=4 m=1 mm_ok=1
**** begin user architecture code

*bias network
*first stage

*output control circuit

**** end user architecture code
.ends
