* PEX produced on Mon Sep 14 15:00:31 CEST 2026 using scripts/sak-pex.sh with m=3 and s=1 (extresist threshold=10000 mOhm, minres=1000 mOhm, mindelay=1 ps)
* NGSPICE file created from opamp_rtr_pex.ext - technology: ihp-sg13cmos5l

.subckt opamp_rtr_pex vdd inp vss inn ibias out
X0 out.t3 a_9288_5041# vss.t28 vss.t31 sg13_hv_nmos ad=0.475p pd=2.88u as=0.475p ps=2.88u w=2.5u l=1u
X1 vdd a_592_286# a_1392_382# vdd sg13_hv_pmos ad=1.425p pd=7.88u as=1.425p ps=7.88u w=7.5u l=4u
X2 w_8388_2366# w_8388_2366# w_8388_2366# w_8388_2366# sg13_hv_pmos ad=0.7125p pd=4.13u as=62.7835p ps=0.25869m w=3.75u l=0.4u
X3 vss.t77 ibias a_442_5111# vss.t109 sg13_hv_nmos ad=0.475p pd=2.88u as=0.475p ps=2.88u w=2.5u l=4u
X4 a_442_5111# a_442_5111# a_442_5111# vss.t3 sg13_hv_nmos ad=0.2375p pd=1.63u as=13.7666p ps=96.82u w=1.25u l=0.45u
X5 out a_1076_5541# vdd vdd sg13_hv_pmos ad=1.425p pd=7.88u as=1.425p ps=7.88u w=7.5u l=1u
X6 vss.t99 vss.t97 vss.t23 vss.t98 sg13_hv_nmos ad=0.85p pd=5.68u as=0 ps=0 w=2.5u l=0.45u
X7 ibias ibias vss.t105 vss.t107 sg13_hv_nmos ad=0.475p pd=2.88u as=0.475p ps=2.88u w=2.5u l=4u
X8 vdd vdd vdd vdd sg13_hv_pmos ad=0.7125p pd=4.13u as=0.18065n ps=0.47106m w=3.75u l=0.4u
X9 w_8388_2366# a_592_286# vdd vdd sg13_hv_pmos ad=1.425p pd=7.88u as=1.425p ps=7.88u w=7.5u l=4u
X10 a_9288_5041# inp w_8388_2366# w_8388_2366# sg13_hv_pmos ad=0.7125p pd=4.13u as=0.7125p ps=4.13u w=3.75u l=2u
X11 a_9288_5041# a_8488_4945# vss.t51 vss.t50 sg13_hv_nmos ad=0.2375p pd=1.63u as=0.2375p ps=1.63u w=1.25u l=4u
X12 a_592_2733# a_592_2733# vdd vdd sg13_hv_pmos ad=0.7125p pd=4.13u as=0.7125p ps=4.13u w=3.75u l=4u
X13 a_442_5111# a_442_5111# a_442_5111# vss.t5 sg13_hv_nmos ad=0.475p pd=2.88u as=0 ps=0 w=2.5u l=0.45u
X14 w_8388_2366# inn a_8488_4945# w_8388_2366# sg13_hv_pmos ad=0.7125p pd=4.13u as=0.7125p ps=4.13u w=3.75u l=2u
X15 w_8388_2366# a_3520_5051# vdd vdd sg13_hv_pmos ad=0.7125p pd=4.13u as=0.7125p ps=4.13u w=3.75u l=4u
X16 out.t1 a_9288_5041# vss.t25 vss.t26 sg13_hv_nmos ad=0.475p pd=2.88u as=0.475p ps=2.88u w=2.5u l=1u
X17 a_592_2733# inn a_442_5111# vss.t63 sg13_hv_nmos ad=0.2375p pd=1.63u as=0.2375p ps=1.63u w=1.25u l=2u
X18 a_12881_4979# a_14767_4615# vss.t65 rhigh l=9u w=1u
X19 w_8388_2366# w_8388_2366# w_8388_2366# w_8388_2366# sg13_hv_pmos ad=2.55p pd=15.68u as=0 ps=0 w=7.5u l=0.4u
X20 a_11355_6131# a_1392_382# a_1392_382# vss.t11 sg13_hv_nmos ad=0.475p pd=2.88u as=0.475p ps=2.88u w=2.5u l=1u
X21 a_442_5111# a_4818_4945# vss.t42 vss.t43 sg13_hv_nmos ad=0.2375p pd=1.63u as=0.2375p ps=1.63u w=1.25u l=4u
X22 a_8488_4945# inn w_8388_2366# w_8388_2366# sg13_hv_pmos ad=0.7125p pd=4.13u as=0.7125p ps=4.13u w=3.75u l=2u
X23 vss.t84 vss.t82 vss.t40 vss.t83 sg13_hv_nmos ad=0.425p pd=3.18u as=0 ps=0 w=1.25u l=0.45u
X24 vss.t35 vss.t35 vss.t34 rhigh l=9u w=1u
X25 a_1076_5541# a_592_2733# vdd vdd sg13_hv_pmos ad=0.7125p pd=4.13u as=0.7125p ps=4.13u w=3.75u l=4u
X26 vss.t21 vss.t78 vss.t7 vss.t79 sg13_hv_nmos ad=0.475p pd=2.88u as=0 ps=0 w=2.5u l=0.45u
X27 a_12881_4251# a_1076_5541# vss.t36 rhigh l=9u w=1u
X28 vdd vdd vdd vdd sg13_hv_pmos ad=1.275p pd=8.18u as=0 ps=0 w=3.75u l=0.4u
X29 a_9288_5041# a_8488_4945# vss.t54 vss.t55 sg13_hv_nmos ad=0.2375p pd=1.63u as=0.2375p ps=1.63u w=1.25u l=4u
X30 a_442_5111# a_592_286# a_3520_5051# vss.t1 sg13_hv_nmos ad=0.475p pd=2.88u as=0.475p ps=2.88u w=2.5u l=1u
X31 vss.t25 a_9288_5041# out.t0 vss.t24 sg13_hv_nmos ad=0.475p pd=2.88u as=0.475p ps=2.88u w=2.5u l=1u
X32 a_1076_5541# a_1076_5541# a_1076_5541# vdd sg13_hv_pmos ad=1.425p pd=7.88u as=34.7735p ps=0.10686m w=7.5u l=1u
X33 vdd a_592_286# a_5933_6071# vdd sg13_hv_pmos ad=1.425p pd=7.88u as=1.425p ps=7.88u w=7.5u l=4u
X34 a_12881_2795# a_14767_3159# vss.t70 rhigh l=9u w=1u
X35 a_442_5111# inn a_592_2733# vss.t62 sg13_hv_nmos ad=0.2375p pd=1.63u as=0.2375p ps=1.63u w=1.25u l=2u
X36 vdd a_1076_5541# out vdd sg13_hv_pmos ad=1.425p pd=7.88u as=1.425p ps=7.88u w=7.5u l=1u
X37 vss.t25 vss.t25 vss.t67 rhigh l=9u w=1u
X38 vss.t9 vss.t80 vss.t81 vss.t12 sg13_hv_nmos ad=0.475p pd=2.88u as=0 ps=0 w=2.5u l=0.45u
X39 vss.t105 ibias a_592_286# vss.t104 sg13_hv_nmos ad=0.475p pd=2.88u as=0.475p ps=2.88u w=2.5u l=4u
X40 vdd vdd vdd vdd sg13_hv_pmos ad=0.7125p pd=4.13u as=0 ps=0 w=3.75u l=0.4u
X41 vss.t16 a_5933_6071# a_5933_6071# vss.t18 sg13_hv_nmos ad=0.475p pd=2.88u as=0.475p ps=2.88u w=2.5u l=4u
X42 vdd a_592_2733# a_1076_5541# vdd sg13_hv_pmos ad=0.7125p pd=4.13u as=0.7125p ps=4.13u w=3.75u l=4u
X43 a_3520_5051# a_592_286# a_442_5111# vss.t0 sg13_hv_nmos ad=0.475p pd=2.88u as=0.475p ps=2.88u w=2.5u l=1u
X44 vdd a_592_2733# a_1076_5541# vdd sg13_hv_pmos ad=0.7125p pd=4.13u as=0.7125p ps=4.13u w=3.75u l=4u
X45 a_9508_346# a_9508_346# vdd vdd sg13_hv_pmos ad=1.425p pd=7.88u as=1.425p ps=7.88u w=7.5u l=1u
X46 vdd a_3520_5051# a_3520_5051# vdd sg13_hv_pmos ad=0.7125p pd=4.13u as=0.7125p ps=4.13u w=3.75u l=4u
X47 a_4818_4945# a_4818_4945# vss.t40 vss.t38 sg13_hv_nmos ad=0.2375p pd=1.63u as=0.2375p ps=1.63u w=1.25u l=4u
X48 a_442_5111# inp a_1076_5541# vss.t64 sg13_hv_nmos ad=0.2375p pd=1.63u as=0.2375p ps=1.63u w=1.25u l=2u
X49 vdd a_3520_5051# a_3520_5051# vdd sg13_hv_pmos ad=0.7125p pd=4.13u as=0.7125p ps=4.13u w=3.75u l=4u
X50 vdd vdd vdd vdd sg13_hv_pmos ad=2.55p pd=15.68u as=0 ps=0 w=7.5u l=0.4u
X51 vss.t42 a_4818_4945# a_4818_4945# vss.t41 sg13_hv_nmos ad=0.2375p pd=1.63u as=0.2375p ps=1.63u w=1.25u l=4u
X52 a_442_5111# ibias vss.t105 vss.t106 sg13_hv_nmos ad=0.475p pd=2.88u as=0.475p ps=2.88u w=2.5u l=4u
X53 w_8388_2366# a_3520_5051# vdd vdd sg13_hv_pmos ad=0.7125p pd=4.13u as=0.7125p ps=4.13u w=3.75u l=4u
X54 a_5933_6071# a_592_286# vdd vdd sg13_hv_pmos ad=1.425p pd=7.88u as=1.425p ps=7.88u w=7.5u l=4u
X55 a_1076_5541# a_592_286# vdd vdd sg13_hv_pmos ad=1.425p pd=7.88u as=1.425p ps=7.88u w=7.5u l=4u
X56 a_4818_4945# a_4818_4945# vss.t42 vss.t43 sg13_hv_nmos ad=0.2375p pd=1.63u as=0.2375p ps=1.63u w=1.25u l=4u
X57 a_442_5111# inp a_1076_5541# vss.t62 sg13_hv_nmos ad=0.2375p pd=1.63u as=0.2375p ps=1.63u w=1.25u l=2u
X58 vss.t92 vss.t90 vss.t39 vss.t83 sg13_hv_nmos ad=0.425p pd=3.18u as=0 ps=0 w=1.25u l=0.45u
X59 w_8388_2366# w_8388_2366# w_8388_2366# w_8388_2366# sg13_hv_pmos ad=0.7125p pd=4.13u as=0 ps=0 w=3.75u l=0.4u
X60 vss.t21 a_5933_6071# a_9288_5041# vss.t20 sg13_hv_nmos ad=0.475p pd=2.88u as=0.475p ps=2.88u w=2.5u l=4u
X61 vss.t57 vss.t87 vss.t89 vss.t88 sg13_hv_nmos ad=0.2375p pd=1.63u as=0 ps=0 w=1.25u l=0.45u
X62 vdd a_1076_5541# out vdd sg13_hv_pmos ad=1.425p pd=7.88u as=1.425p ps=7.88u w=7.5u l=1u
X63 vss.t45 vss.t85 vss.t52 vss.t86 sg13_hv_nmos ad=0.2375p pd=1.63u as=0 ps=0 w=1.25u l=0.45u
X64 a_9288_5041# a_9288_5041# a_9288_5041# vss.t12 sg13_hv_nmos ad=0.85p pd=5.68u as=17.3283p ps=85.93999u w=2.5u l=1u
X65 vdd vdd vdd vdd sg13_hv_pmos ad=1.425p pd=7.88u as=0 ps=0 w=7.5u l=0.4u
X66 a_9288_5041# a_9288_5041# a_9288_5041# vss.t12 sg13_hv_nmos ad=0.475p pd=2.88u as=0 ps=0 w=2.5u l=1u
X67 a_8488_4945# inn w_8388_2366# w_8388_2366# sg13_hv_pmos ad=0.7125p pd=4.13u as=0.7125p ps=4.13u w=3.75u l=2u
X68 a_8488_4945# a_8488_4945# vss.t54 vss.t55 sg13_hv_nmos ad=0.2375p pd=1.63u as=0.2375p ps=1.63u w=1.25u l=4u
X69 w_8388_2366# w_8388_2366# w_8388_2366# w_8388_2366# sg13_hv_pmos ad=1.275p pd=8.18u as=0 ps=0 w=3.75u l=0.4u
X70 vss.t74 vss.t71 vss.t73 vss.t72 sg13_hv_nmos ad=0.85p pd=5.68u as=0 ps=0 w=2.5u l=0.45u
X71 a_12881_3523# a_9288_5041# vss.t49 rhigh l=9u w=1u
X72 vdd a_592_286# a_1076_5541# vdd sg13_hv_pmos ad=1.425p pd=7.88u as=1.425p ps=7.88u w=7.5u l=4u
X73 a_592_2733# inn a_442_5111# vss.t61 sg13_hv_nmos ad=0.2375p pd=1.63u as=0.2375p ps=1.63u w=1.25u l=2u
X74 a_442_5111# inn a_592_2733# vss.t64 sg13_hv_nmos ad=0.2375p pd=1.63u as=0.2375p ps=1.63u w=1.25u l=2u
X75 a_1392_382# a_1392_382# a_11355_6131# vss.t10 sg13_hv_nmos ad=0.475p pd=2.88u as=0.475p ps=2.88u w=2.5u l=1u
X76 a_9288_5041# inp w_8388_2366# w_8388_2366# sg13_hv_pmos ad=0.7125p pd=4.13u as=0.7125p ps=4.13u w=3.75u l=2u
X77 vss.t16 a_5933_6071# a_6733_6167# vss.t15 sg13_hv_nmos ad=0.475p pd=2.88u as=0.475p ps=2.88u w=2.5u l=4u
X78 out.t0 a_9288_5041# vss.t23 vss.t22 sg13_hv_nmos ad=0.475p pd=2.88u as=0.475p ps=2.88u w=2.5u l=1u
X79 a_1076_5541# a_6733_6167# a_9288_5041# vdd sg13_hv_pmos ad=1.425p pd=7.88u as=1.425p ps=7.88u w=7.5u l=1u
X80 vdd a_9508_346# a_9508_346# vdd sg13_hv_pmos ad=1.425p pd=7.88u as=1.425p ps=7.88u w=7.5u l=1u
X81 a_12881_4251# a_14767_4615# vss.t66 rhigh l=9u w=1u
X82 a_5933_6071# a_5933_6071# vss.t16 vss.t17 sg13_hv_nmos ad=0.475p pd=2.88u as=0.475p ps=2.88u w=2.5u l=4u
X83 a_442_5111# a_442_5111# a_442_5111# vss.t2 sg13_hv_nmos ad=0.425p pd=3.18u as=0 ps=0 w=1.25u l=0.45u
X84 a_1076_5541# a_592_2733# vdd vdd sg13_hv_pmos ad=0.7125p pd=4.13u as=0.7125p ps=4.13u w=3.75u l=4u
X85 vss.t77 vss.t75 vss.t14 vss.t76 sg13_hv_nmos ad=0.475p pd=2.88u as=0 ps=0 w=2.5u l=0.45u
X86 vdd vdd vdd vdd sg13_hv_pmos ad=1.425p pd=7.88u as=0 ps=0 w=7.5u l=0.4u
X87 a_442_5111# a_4818_4945# vss.t39 vss.t38 sg13_hv_nmos ad=0.2375p pd=1.63u as=0.2375p ps=1.63u w=1.25u l=4u
X88 a_9508_346# a_6733_6167# a_6733_6167# vdd sg13_hv_pmos ad=1.425p pd=7.88u as=1.425p ps=7.88u w=7.5u l=1u
X89 vss.t105 ibias ibias vss.t108 sg13_hv_nmos ad=0.475p pd=2.88u as=0.475p ps=2.88u w=2.5u l=4u
X90 vss.t28 a_9288_5041# out.t2 vss.t30 sg13_hv_nmos ad=0.475p pd=2.88u as=0.475p ps=2.88u w=2.5u l=1u
X91 out a_1076_5541# vdd vdd sg13_hv_pmos ad=1.425p pd=7.88u as=1.425p ps=7.88u w=7.5u l=1u
X92 vss.t42 a_4818_4945# a_442_5111# vss.t41 sg13_hv_nmos ad=0.2375p pd=1.63u as=0.2375p ps=1.63u w=1.25u l=4u
X93 a_4818_4945# a_592_286# w_8388_2366# w_8388_2366# sg13_hv_pmos ad=1.425p pd=7.88u as=1.425p ps=7.88u w=7.5u l=1u
X94 a_11355_6131# a_11355_6131# vss.t7 vss.t6 sg13_hv_nmos ad=0.475p pd=2.88u as=0.475p ps=2.88u w=2.5u l=1u
X95 a_592_2733# a_592_2733# vdd vdd sg13_hv_pmos ad=0.7125p pd=4.13u as=0.7125p ps=4.13u w=3.75u l=4u
X96 vss.t9 a_11355_6131# a_11355_6131# vss.t8 sg13_hv_nmos ad=0.475p pd=2.88u as=0.475p ps=2.88u w=2.5u l=1u
X97 vss.t54 a_8488_4945# a_8488_4945# vss.t53 sg13_hv_nmos ad=0.2375p pd=1.63u as=0.2375p ps=1.63u w=1.25u l=4u
X98 a_9288_5041# a_6733_6167# a_1076_5541# vdd sg13_hv_pmos ad=1.425p pd=7.88u as=1.425p ps=7.88u w=7.5u l=1u
X99 vdd vdd vdd vdd sg13_hv_pmos ad=0.7125p pd=4.13u as=0 ps=0 w=3.75u l=0.4u
X100 vdd vdd vdd vdd sg13_hv_pmos ad=1.275p pd=8.18u as=0 ps=0 w=3.75u l=0.4u
X101 w_8388_2366# inn a_8488_4945# w_8388_2366# sg13_hv_pmos ad=0.7125p pd=4.13u as=0.7125p ps=4.13u w=3.75u l=2u
X102 vss.t45 a_4818_4945# a_442_5111# vss.t44 sg13_hv_nmos ad=0.2375p pd=1.63u as=0.2375p ps=1.63u w=1.25u l=4u
X103 a_1076_5541# inp a_442_5111# vss.t61 sg13_hv_nmos ad=0.2375p pd=1.63u as=0.2375p ps=1.63u w=1.25u l=2u
X104 vss.t60 vss.t95 vss.t96 vss.t88 sg13_hv_nmos ad=0.2375p pd=1.63u as=0 ps=0 w=1.25u l=0.45u
X105 a_1076_5541# a_1392_382# a_9288_5041# vss.t12 sg13_hv_nmos ad=0.475p pd=2.88u as=0.475p ps=2.88u w=2.5u l=1u
X106 a_3520_5051# a_3520_5051# vdd vdd sg13_hv_pmos ad=0.7125p pd=4.13u as=0.7125p ps=4.13u w=3.75u l=4u
X107 vss.t48 vss.t93 vss.t51 vss.t86 sg13_hv_nmos ad=0.2375p pd=1.63u as=0 ps=0 w=1.25u l=0.45u
X108 a_442_5111# a_442_5111# a_442_5111# vss.t2 sg13_hv_nmos ad=0.425p pd=3.18u as=0 ps=0 w=1.25u l=0.45u
X109 out.t2 a_9288_5041# vss.t28 vss.t29 sg13_hv_nmos ad=0.475p pd=2.88u as=0.475p ps=2.88u w=2.5u l=1u
X110 vdd a_592_286# w_8388_2366# vdd sg13_hv_pmos ad=1.425p pd=7.88u as=1.425p ps=7.88u w=7.5u l=4u
X111 vss.t57 a_8488_4945# a_9288_5041# vss.t56 sg13_hv_nmos ad=0.2375p pd=1.63u as=0.2375p ps=1.63u w=1.25u l=4u
X112 w_8388_2366# w_8388_2366# w_8388_2366# w_8388_2366# sg13_hv_pmos ad=1.425p pd=7.88u as=0 ps=0 w=7.5u l=0.4u
X113 vdd a_592_286# a_592_286# vdd sg13_hv_pmos ad=1.425p pd=7.88u as=1.425p ps=7.88u w=7.5u l=4u
X114 w_8388_2366# inp a_9288_5041# w_8388_2366# sg13_hv_pmos ad=0.7125p pd=4.13u as=0.7125p ps=4.13u w=3.75u l=2u
X115 vss.t28 a_9288_5041# out.t1 vss.t27 sg13_hv_nmos ad=0.475p pd=2.88u as=0.475p ps=2.88u w=2.5u l=1u
X116 vdd a_592_2733# a_592_2733# vdd sg13_hv_pmos ad=0.7125p pd=4.13u as=0.7125p ps=4.13u w=3.75u l=4u
X117 out a_1076_5541# vdd vdd sg13_hv_pmos ad=1.425p pd=7.88u as=1.425p ps=7.88u w=7.5u l=1u
X118 vdd a_3520_5051# w_8388_2366# vdd sg13_hv_pmos ad=0.7125p pd=4.13u as=0.7125p ps=4.13u w=3.75u l=4u
X119 a_9288_5041# a_1392_382# a_1076_5541# vss.t12 sg13_hv_nmos ad=0.475p pd=2.88u as=0.475p ps=2.88u w=2.5u l=1u
X120 a_1392_382# a_592_286# vdd vdd sg13_hv_pmos ad=1.425p pd=7.88u as=1.425p ps=7.88u w=7.5u l=4u
X121 w_8388_2366# w_8388_2366# w_8388_2366# w_8388_2366# sg13_hv_pmos ad=1.275p pd=8.18u as=0 ps=0 w=3.75u l=0.4u
X122 a_3520_5051# a_3520_5051# vdd vdd sg13_hv_pmos ad=0.7125p pd=4.13u as=0.7125p ps=4.13u w=3.75u l=4u
X123 a_12881_4979# a_14767_5343# vss.t37 rhigh l=9u w=1u
X124 a_9288_5041# a_5933_6071# vss.t16 vss.t19 sg13_hv_nmos ad=0.475p pd=2.88u as=0.475p ps=2.88u w=2.5u l=4u
X125 vdd a_1076_5541# out vdd sg13_hv_pmos ad=1.425p pd=7.88u as=1.425p ps=7.88u w=7.5u l=1u
X126 vss.t33 vss.t100 vss.t102 vss.t101 sg13_hv_nmos ad=0.475p pd=2.88u as=0 ps=0 w=2.5u l=0.45u
X127 a_12881_2795# a_14767_2795# vss.t68 rhigh l=9u w=1u
X128 w_8388_2366# a_592_286# a_4818_4945# w_8388_2366# sg13_hv_pmos ad=1.425p pd=7.88u as=1.425p ps=7.88u w=7.5u l=1u
X129 a_8488_4945# a_8488_4945# vss.t52 vss.t50 sg13_hv_nmos ad=0.2375p pd=1.63u as=0.2375p ps=1.63u w=1.25u l=4u
X130 vdd vdd vdd vdd sg13_hv_pmos ad=0.7125p pd=4.13u as=0 ps=0 w=3.75u l=0.4u
X131 vdd a_592_2733# a_592_2733# vdd sg13_hv_pmos ad=0.7125p pd=4.13u as=0.7125p ps=4.13u w=3.75u l=4u
X132 vss.t54 a_8488_4945# a_9288_5041# vss.t53 sg13_hv_nmos ad=0.2375p pd=1.63u as=0.2375p ps=1.63u w=1.25u l=4u
X133 a_12881_3523# a_14767_3159# vss.t69 rhigh l=9u w=1u
X134 vdd a_3520_5051# w_8388_2366# vdd sg13_hv_pmos ad=0.7125p pd=4.13u as=0.7125p ps=4.13u w=3.75u l=4u
X135 a_442_5111# a_442_5111# a_442_5111# vss.t4 sg13_hv_nmos ad=0.85p pd=5.68u as=0 ps=0 w=2.5u l=0.45u
X136 vdd vdd vdd vdd sg13_hv_pmos ad=2.55p pd=15.68u as=0 ps=0 w=7.5u l=0.4u
X137 a_592_286# a_592_286# vdd vdd sg13_hv_pmos ad=1.425p pd=7.88u as=1.425p ps=7.88u w=7.5u l=4u
X138 vss.t48 a_4818_4945# a_4818_4945# vss.t44 sg13_hv_nmos ad=0.2375p pd=1.63u as=0.2375p ps=1.63u w=1.25u l=4u
X139 a_442_5111# a_442_5111# a_442_5111# vss.t3 sg13_hv_nmos ad=0.2375p pd=1.63u as=0 ps=0 w=1.25u l=0.45u
X140 vdd vdd vdd vdd sg13_hv_pmos ad=1.425p pd=7.88u as=0 ps=0 w=7.5u l=0.4u
X141 a_592_286# ibias vss.t73 vss.t103 sg13_hv_nmos ad=0.475p pd=2.88u as=0.475p ps=2.88u w=2.5u l=4u
X142 vss.t33 a_9288_5041# out.t3 vss.t32 sg13_hv_nmos ad=0.475p pd=2.88u as=0.475p ps=2.88u w=2.5u l=1u
X143 out a_1076_5541# vdd vdd sg13_hv_pmos ad=1.425p pd=7.88u as=1.425p ps=7.88u w=7.5u l=1u
X144 a_1076_5541# a_1076_5541# a_1076_5541# vdd sg13_hv_pmos ad=2.55p pd=15.68u as=0 ps=0 w=7.5u l=1u
X145 vss.t60 a_8488_4945# a_8488_4945# vss.t56 sg13_hv_nmos ad=0.2375p pd=1.63u as=0.2375p ps=1.63u w=1.25u l=4u
X146 a_1076_5541# inp a_442_5111# vss.t63 sg13_hv_nmos ad=0.2375p pd=1.63u as=0.2375p ps=1.63u w=1.25u l=2u
X147 a_6733_6167# a_6733_6167# a_9508_346# vdd sg13_hv_pmos ad=1.425p pd=7.88u as=1.425p ps=7.88u w=7.5u l=1u
X148 w_8388_2366# inp a_9288_5041# w_8388_2366# sg13_hv_pmos ad=0.7125p pd=4.13u as=0.7125p ps=4.13u w=3.75u l=2u
X149 a_6733_6167# a_5933_6071# vss.t14 vss.t13 sg13_hv_nmos ad=0.475p pd=2.88u as=0.475p ps=2.88u w=2.5u l=4u
X150 vdd a_1076_5541# out vdd sg13_hv_pmos ad=1.425p pd=7.88u as=1.425p ps=7.88u w=7.5u l=1u
R0 out.t0 out.t3 3.11994
R1 out.t0 out.t2 2.74044
R2 out.t0 out.t1 2.74044
R3 out out.t0 1.21737
R4 vss.n374 vss.n373 55358.3
R5 vss.t22 vss.n1 53.2619
R6 vss.n2 vss.t5 17.3475
R7 vss.n4 vss.n159 93.268
R8 vss.n18 vss.n371 42.3704
R9 vss.n17 vss.n5 1.46363
R10 vss.t1 vss.n161 85.7681
R11 vss.n371 vss.n17 85.9151
R12 vss.n19 vss.t8 26.3344
R13 vss.n5 vss.n7 0.0240826
R14 vss.t0 vss.n3 82.4923
R15 vss.n257 vss.n76 80.4072
R16 vss.n256 vss.n45 80.4072
R17 vss.n255 vss.n75 80.4072
R18 vss.n254 vss.n46 80.4072
R19 vss.n250 vss.n74 80.4072
R20 vss.n249 vss.n47 80.4072
R21 vss.n248 vss.n73 80.4072
R22 vss.n247 vss.n48 80.4072
R23 vss.n246 vss.n72 80.4072
R24 vss.n245 vss.n49 80.4072
R25 vss.n244 vss.n71 80.4072
R26 vss.n241 vss.n51 80.4072
R27 vss.n240 vss.n69 80.4072
R28 vss.n239 vss.n52 80.4072
R29 vss.n238 vss.n68 80.4072
R30 vss.n237 vss.n53 80.4072
R31 vss.n236 vss.n67 80.4072
R32 vss.n235 vss.n54 80.4072
R33 vss.n233 vss.n55 80.4072
R34 vss.n232 vss.n65 80.4072
R35 vss.n229 vss.n57 80.4072
R36 vss.n228 vss.n63 80.4072
R37 vss.n226 vss.n62 80.4072
R38 vss.n225 vss.n59 80.4072
R39 vss.n224 vss.n61 80.4072
R40 vss.n141 vss.n104 78.7062
R41 vss.n140 vss.n105 78.7062
R42 vss.n137 vss.n108 78.7062
R43 vss.n136 vss.n109 78.7062
R44 vss.n135 vss.n110 78.7062
R45 vss.n134 vss.n111 78.7062
R46 vss.n133 vss.n112 78.7062
R47 vss.n132 vss.n113 78.7062
R48 vss.n130 vss.n115 78.7062
R49 vss.n129 vss.n116 78.7062
R50 vss.n128 vss.n117 78.7062
R51 vss.n127 vss.n118 78.7062
R52 vss.n125 vss.n120 78.7062
R53 vss.n124 vss.n121 78.7062
R54 vss.n123 vss.n122 78.7062
R55 vss.n0 vss.t22 76.9772
R56 vss.t29 vss.n7 31.5246
R57 vss.n6 vss.t24 71.2785
R58 vss.t27 vss.n7 32.3046
R59 vss.n5 vss.t106 28.8749
R60 vss.n5 vss.n6 0.224791
R61 vss.t26 vss.n6 32.4545
R62 vss.t79 vss.n66 63.7713
R63 vss.t83 vss.n21 21.2527
R64 vss.t4 vss.n4 60.4759
R65 vss.n258 vss.t19 59.6123
R66 vss.t24 vss.n0 59.2082
R67 vss.t108 vss.n160 58.2211
R68 vss.t61 vss.n107 57.718
R69 vss.t62 vss.n114 57.718
R70 vss.n3 vss.t4 57.5678
R71 vss.n139 vss.t104 56.4063
R72 vss.n161 vss.t108 55.5976
R73 vss.n157 vss.n87 52.471
R74 vss.n156 vss.n88 52.471
R75 vss.n155 vss.n89 52.471
R76 vss.n154 vss.n90 52.471
R77 vss.n153 vss.n91 52.471
R78 vss.n152 vss.n92 52.471
R79 vss.n150 vss.n94 52.471
R80 vss.n149 vss.n95 52.471
R81 vss.n148 vss.n96 52.471
R82 vss.n147 vss.n97 52.471
R83 vss.n146 vss.n98 52.471
R84 vss.n145 vss.n99 52.471
R85 vss.n143 vss.n101 52.471
R86 vss.n142 vss.n102 52.471
R87 vss.n223 vss.t11 51.2944
R88 vss.t56 vss.n64 49.9081
R89 vss.n142 vss.n103 49.0388
R90 vss.n242 vss.t20 48.5218
R91 vss.n5 vss.t30 30.1005
R92 vss.n307 vss.n21 52.9475
R93 vss.n316 vss.n162 47.2239
R94 vss.n306 vss.n163 47.2239
R95 vss.n317 vss.n164 47.2239
R96 vss.n305 vss.n165 47.2239
R97 vss.n318 vss.n166 47.2239
R98 vss.n304 vss.n167 47.2239
R99 vss.n320 vss.n170 47.2239
R100 vss.n302 vss.n171 47.2239
R101 vss.n321 vss.n172 47.2239
R102 vss.n301 vss.n173 47.2239
R103 vss.n322 vss.n174 47.2239
R104 vss.n300 vss.n175 47.2239
R105 vss.n323 vss.n176 47.2239
R106 vss.n299 vss.n177 47.2239
R107 vss.n324 vss.n178 47.2239
R108 vss.n298 vss.n179 47.2239
R109 vss.n325 vss.n180 47.2239
R110 vss.n326 vss.n182 47.2239
R111 vss.n296 vss.n183 47.2239
R112 vss.n327 vss.n184 47.2239
R113 vss.n295 vss.n185 47.2239
R114 vss.n328 vss.n186 47.2239
R115 vss.n294 vss.n187 47.2239
R116 vss.n329 vss.n188 47.2239
R117 vss.n293 vss.n189 47.2239
R118 vss.n330 vss.n190 47.2239
R119 vss.n292 vss.n191 47.2239
R120 vss.n331 vss.n192 47.2239
R121 vss.n291 vss.n193 47.2239
R122 vss.n332 vss.n194 47.2239
R123 vss.n290 vss.n195 47.2239
R124 vss.n333 vss.n196 47.2239
R125 vss.n334 vss.n198 47.2239
R126 vss.n288 vss.n199 47.2239
R127 vss.n335 vss.n200 47.2239
R128 vss.n287 vss.n201 47.2239
R129 vss.n336 vss.n202 47.2239
R130 vss.n286 vss.n203 47.2239
R131 vss.n337 vss.n204 47.2239
R132 vss.n285 vss.n205 47.2239
R133 vss.n340 vss.n206 47.2239
R134 vss.n284 vss.n207 47.2239
R135 vss.n380 vss.n208 47.2239
R136 vss.n379 vss.n209 47.2239
R137 vss.n377 vss.n211 47.2239
R138 vss.n376 vss.n213 47.2239
R139 vss.n385 vss.n384 47.1354
R140 vss.n384 vss.n34 47.1354
R141 vss.n277 vss.n34 47.1354
R142 vss.n277 vss.n86 47.1354
R143 vss.n276 vss.n86 47.1354
R144 vss.n276 vss.n35 47.1354
R145 vss.n275 vss.n35 47.1354
R146 vss.n275 vss.n85 47.1354
R147 vss.n274 vss.n85 47.1354
R148 vss.n274 vss.n36 47.1354
R149 vss.n273 vss.n36 47.1354
R150 vss.n273 vss.n84 47.1354
R151 vss.n272 vss.n84 47.1354
R152 vss.n272 vss.n37 47.1354
R153 vss.n271 vss.n83 47.1354
R154 vss.n270 vss.n38 47.1354
R155 vss.n269 vss.n38 47.1354
R156 vss.n269 vss.n82 47.1354
R157 vss.n268 vss.n82 47.1354
R158 vss.n268 vss.n39 47.1354
R159 vss.n267 vss.n39 47.1354
R160 vss.n267 vss.n81 47.1354
R161 vss.n266 vss.n81 47.1354
R162 vss.n266 vss.n40 47.1354
R163 vss.n265 vss.n40 47.1354
R164 vss.n265 vss.n80 47.1354
R165 vss.n264 vss.n80 47.1354
R166 vss.n264 vss.n41 47.1354
R167 vss.n263 vss.n41 47.1354
R168 vss.n263 vss.n79 47.1354
R169 vss.n262 vss.n79 47.1354
R170 vss.n262 vss.n42 47.1354
R171 vss.n261 vss.n42 47.1354
R172 vss.n261 vss.n78 47.1354
R173 vss.n260 vss.n78 47.1354
R174 vss.n260 vss.n43 47.1354
R175 vss.n259 vss.n43 47.1354
R176 vss.n259 vss.n77 47.1354
R177 vss.n126 vss.t107 45.9122
R178 vss.t86 vss.n214 45.9122
R179 vss.n227 vss.t10 45.7491
R180 vss.n385 vss.t86 44.1834
R181 vss.t15 vss.n197 43.2887
R182 vss.n307 vss.n162 41.9769
R183 vss.n316 vss.n163 41.9769
R184 vss.n306 vss.n164 41.9769
R185 vss.n317 vss.n165 41.9769
R186 vss.n305 vss.n166 41.9769
R187 vss.n318 vss.n167 41.9769
R188 vss.n304 vss.n168 41.9769
R189 vss.n319 vss.n169 41.9769
R190 vss.n303 vss.n170 41.9769
R191 vss.n320 vss.n171 41.9769
R192 vss.n302 vss.n172 41.9769
R193 vss.n321 vss.n173 41.9769
R194 vss.n301 vss.n174 41.9769
R195 vss.n322 vss.n175 41.9769
R196 vss.n300 vss.n176 41.9769
R197 vss.n299 vss.n178 41.9769
R198 vss.n324 vss.n179 41.9769
R199 vss.n298 vss.n180 41.9769
R200 vss.n325 vss.n181 41.9769
R201 vss.n297 vss.n182 41.9769
R202 vss.n326 vss.n183 41.9769
R203 vss.n296 vss.n184 41.9769
R204 vss.n295 vss.n186 41.9769
R205 vss.n328 vss.n187 41.9769
R206 vss.n294 vss.n188 41.9769
R207 vss.n329 vss.n189 41.9769
R208 vss.n293 vss.n190 41.9769
R209 vss.n330 vss.n191 41.9769
R210 vss.n292 vss.n192 41.9769
R211 vss.n331 vss.n193 41.9769
R212 vss.n332 vss.n195 41.9769
R213 vss.n290 vss.n196 41.9769
R214 vss.n333 vss.n197 41.9769
R215 vss.n289 vss.n198 41.9769
R216 vss.n334 vss.n199 41.9769
R217 vss.n288 vss.n200 41.9769
R218 vss.n335 vss.n201 41.9769
R219 vss.n287 vss.n202 41.9769
R220 vss.n336 vss.n203 41.9769
R221 vss.n286 vss.n204 41.9769
R222 vss.n337 vss.n205 41.9769
R223 vss.n285 vss.n206 41.9769
R224 vss.n284 vss.n208 41.9769
R225 vss.n380 vss.n209 41.9769
R226 vss.n379 vss.n210 41.9769
R227 vss.n378 vss.n211 41.9769
R228 vss.n377 vss.n212 41.9769
R229 vss.n375 vss.n213 41.9769
R230 vss.n376 vss.n214 41.9769
R231 vss.n258 vss.t53 41.5901
R232 vss.n243 vss.t55 41.5901
R233 vss.n231 vss.t6 40.2038
R234 vss.t6 vss.n56 40.2038
R235 vss.n17 vss.t31 26.8272
R236 vss.n297 vss.t41 39.3534
R237 vss.n291 vss.t43 39.3534
R238 vss.t68 vss.n368 39.0202
R239 vss.t49 vss.n365 39.0202
R240 vss.t55 vss.n50 38.8175
R241 vss.t65 vss.n362 37.348
R242 vss.n23 vss.n22 14.1134
R243 vss.n158 vss.n87 36.7298
R244 vss.n157 vss.n88 36.7298
R245 vss.n155 vss.n90 36.7298
R246 vss.n154 vss.n91 36.7298
R247 vss.n153 vss.n92 36.7298
R248 vss.n152 vss.n93 36.7298
R249 vss.n150 vss.n95 36.7298
R250 vss.n149 vss.n96 36.7298
R251 vss.n148 vss.n97 36.7298
R252 vss.n147 vss.n98 36.7298
R253 vss.n146 vss.n99 36.7298
R254 vss.n145 vss.n100 36.7298
R255 vss.n144 vss.n101 36.7298
R256 vss.n143 vss.n102 36.7298
R257 vss.n323 vss.t76 36.7298
R258 vss.n18 vss.t32 25.2567
R259 vss.t13 vss.n185 35.4181
R260 vss.t37 vss.n20 27.395
R261 vss.t10 vss.n58 34.6585
R262 vss.n158 vss.t72 34.1063
R263 vss.n19 vss.n5 0.0952203
R264 vss.n160 vss.t0 33.2976
R265 vss.n364 vss.t66 33.1702
R266 vss.t2 vss.n89 32.7946
R267 vss.t107 vss.n119 32.7946
R268 vss.t17 vss.n210 32.7946
R269 vss.t20 vss.n70 31.8859
R270 vss.n367 vss.t69 31.514
R271 vss.n370 vss.t67 31.4979
R272 vss.t63 vss.n93 31.4828
R273 vss.t64 vss.n100 31.4828
R274 vss.n375 vss.n374 31.4828
R275 vss.n271 vss.t50 30.4996
R276 vss.n230 vss.t56 30.4996
R277 vss.t11 vss.n60 29.1133
R278 vss.t70 vss.n367 28.9915
R279 vss.t36 vss.n364 28.9868
R280 vss.n319 vss.t38 28.8593
R281 vss.n340 vss.t44 28.8593
R282 vss.n373 vss.n372 28.1986
R283 vss.t98 vss.n1 22.0289
R284 vss.n151 vss.t103 24.924
R285 vss.t109 vss.n169 24.924
R286 vss.n362 vss.t37 24.809
R287 vss.t18 vss.n83 23.568
R288 vss.n270 vss.t18 23.568
R289 vss.n368 vss.t70 23.1367
R290 vss.n365 vss.t36 23.1367
R291 vss.n141 vss.n103 22.8035
R292 vss.n373 vss.n370 22.7159
R293 vss.t104 vss.n106 22.3005
R294 vss.n303 vss.t109 22.3005
R295 vss.n2 vss.t1 30.3123
R296 vss.n151 vss.t63 20.9887
R297 vss.n144 vss.t64 20.9887
R298 vss.n138 vss.t61 20.9887
R299 vss.n131 vss.t62 20.9887
R300 vss.t19 vss.n44 20.7953
R301 vss.t67 vss.n369 20.7093
R302 vss.t69 vss.n366 20.7093
R303 vss.t101 vss.n5 16.3868
R304 vss.t66 vss.n363 19.0371
R305 vss.t72 vss.n22 27.0464
R306 vss.t38 vss.n168 18.3652
R307 vss.t12 vss.n5 11.873
R308 vss.n5 vss.n389 17.0005
R309 vss.n5 vss.n31 17.0005
R310 vss.n386 vss.n5 17.0005
R311 vss.n14 vss.n5 8.49485
R312 vss.n13 vss.n14 0.0132937
R313 vss.n5 vss.n30 17.0005
R314 vss.n5 vss.n25 8.49485
R315 vss.n11 vss.n5 0.897762
R316 vss.n23 vss.n26 17.0005
R317 vss.n388 vss.n23 17.0005
R318 vss.n23 vss.n32 17.0005
R319 vss.n23 vss.n387 17.0005
R320 vss.n23 vss.n12 8.49711
R321 vss.n23 vss.n33 17.0005
R322 vss.n10 vss.n25 0.0935378
R323 vss.n10 vss.n23 2.40037
R324 vss.n10 vss.n11 0.0908325
R325 vss.n283 vss.t45 17.0005
R326 vss.t85 vss.t52 17.0005
R327 vss.n381 vss.n252 17.0005
R328 vss.n382 vss.n381 17.0005
R329 vss.n383 vss.n252 17.0005
R330 vss.n383 vss.n382 17.0005
R331 vss.t48 vss.t93 17.0005
R332 vss.n280 vss.t51 17.0005
R333 vss.n383 vss.n218 17.0005
R334 vss.n383 vss.n222 17.0005
R335 vss.n221 vss.t57 17.0005
R336 vss.t87 vss.t89 17.0005
R337 vss.t60 vss.t95 17.0005
R338 vss.n217 vss.t96 17.0005
R339 vss.n5 vss.n385 17.0005
R340 vss.n5 vss.n34 17.0005
R341 vss.n5 vss.n86 17.0005
R342 vss.n5 vss.n35 17.0005
R343 vss.n5 vss.n85 17.0005
R344 vss.n5 vss.n36 17.0005
R345 vss.n5 vss.n84 17.0005
R346 vss.n5 vss.n37 17.0005
R347 vss.n5 vss.n83 17.0005
R348 vss.n5 vss.n38 17.0005
R349 vss.n5 vss.n82 17.0005
R350 vss.n5 vss.n39 17.0005
R351 vss.n5 vss.n81 17.0005
R352 vss.n5 vss.n40 17.0005
R353 vss.n5 vss.n80 17.0005
R354 vss.n5 vss.n41 17.0005
R355 vss.n5 vss.n79 17.0005
R356 vss.n5 vss.n42 17.0005
R357 vss.n5 vss.n78 17.0005
R358 vss.n5 vss.n43 17.0005
R359 vss.n5 vss.n77 17.0005
R360 vss.n5 vss.n44 17.0005
R361 vss.n5 vss.n76 17.0005
R362 vss.n5 vss.n45 17.0005
R363 vss.n5 vss.n75 17.0005
R364 vss.n5 vss.n46 17.0005
R365 vss.n5 vss.n74 17.0005
R366 vss.n5 vss.n47 17.0005
R367 vss.n5 vss.n73 17.0005
R368 vss.n5 vss.n48 17.0005
R369 vss.n5 vss.n72 17.0005
R370 vss.n5 vss.n49 17.0005
R371 vss.n5 vss.n71 17.0005
R372 vss.n5 vss.n50 17.0005
R373 vss.n5 vss.n70 17.0005
R374 vss.n5 vss.n51 17.0005
R375 vss.n5 vss.n69 17.0005
R376 vss.n5 vss.n52 17.0005
R377 vss.n5 vss.n68 17.0005
R378 vss.n5 vss.n53 17.0005
R379 vss.n5 vss.n67 17.0005
R380 vss.n5 vss.n54 17.0005
R381 vss.n5 vss.n66 17.0005
R382 vss.n5 vss.n55 17.0005
R383 vss.n5 vss.n65 17.0005
R384 vss.n5 vss.n56 17.0005
R385 vss.n5 vss.n64 17.0005
R386 vss.n5 vss.n57 17.0005
R387 vss.n5 vss.n63 17.0005
R388 vss.n5 vss.n58 17.0005
R389 vss.n5 vss.n62 17.0005
R390 vss.n5 vss.n59 17.0005
R391 vss.n5 vss.n61 17.0005
R392 vss.n5 vss.n60 17.0005
R393 vss.n5 vss.n22 4.83335
R394 vss.n5 vss.n87 17.0005
R395 vss.n5 vss.n88 17.0005
R396 vss.n5 vss.n89 17.0005
R397 vss.n5 vss.n90 17.0005
R398 vss.n5 vss.n91 17.0005
R399 vss.n5 vss.n92 17.0005
R400 vss.n5 vss.n93 17.0005
R401 vss.n5 vss.n94 17.0005
R402 vss.n5 vss.n95 17.0005
R403 vss.n5 vss.n96 17.0005
R404 vss.n5 vss.n97 17.0005
R405 vss.n5 vss.n98 17.0005
R406 vss.n5 vss.n99 17.0005
R407 vss.n5 vss.n100 17.0005
R408 vss.n5 vss.n101 17.0005
R409 vss.n5 vss.n102 17.0005
R410 vss.n5 vss.n104 17.0005
R411 vss.n5 vss.n105 17.0005
R412 vss.n5 vss.n106 17.0005
R413 vss.n5 vss.n107 17.0005
R414 vss.n5 vss.n108 17.0005
R415 vss.n5 vss.n109 17.0005
R416 vss.n5 vss.n110 17.0005
R417 vss.n5 vss.n111 17.0005
R418 vss.n5 vss.n112 17.0005
R419 vss.n5 vss.n113 17.0005
R420 vss.n5 vss.n114 17.0005
R421 vss.n5 vss.n115 17.0005
R422 vss.n5 vss.n116 17.0005
R423 vss.n5 vss.n117 17.0005
R424 vss.n5 vss.n118 17.0005
R425 vss.n5 vss.n119 17.0005
R426 vss.n5 vss.n120 17.0005
R427 vss.n5 vss.n121 17.0005
R428 vss.n5 vss.n122 17.0005
R429 vss.n5 vss.n21 8.88535
R430 vss.n5 vss.n162 17.0005
R431 vss.n5 vss.n163 17.0005
R432 vss.n5 vss.n164 17.0005
R433 vss.n5 vss.n165 17.0005
R434 vss.n5 vss.n166 17.0005
R435 vss.n5 vss.n167 17.0005
R436 vss.n5 vss.n168 17.0005
R437 vss.n5 vss.n169 17.0005
R438 vss.n5 vss.n170 17.0005
R439 vss.n5 vss.n171 17.0005
R440 vss.n5 vss.n172 17.0005
R441 vss.n5 vss.n173 17.0005
R442 vss.n5 vss.n174 17.0005
R443 vss.n5 vss.n175 17.0005
R444 vss.n5 vss.n176 17.0005
R445 vss.n5 vss.n177 17.0005
R446 vss.n5 vss.n178 17.0005
R447 vss.n5 vss.n179 17.0005
R448 vss.n5 vss.n180 17.0005
R449 vss.n5 vss.n181 17.0005
R450 vss.n5 vss.n182 17.0005
R451 vss.n5 vss.n183 17.0005
R452 vss.n5 vss.n184 17.0005
R453 vss.n5 vss.n185 17.0005
R454 vss.n5 vss.n186 17.0005
R455 vss.n5 vss.n187 17.0005
R456 vss.n5 vss.n188 17.0005
R457 vss.n5 vss.n189 17.0005
R458 vss.n5 vss.n190 17.0005
R459 vss.n5 vss.n191 17.0005
R460 vss.n5 vss.n192 17.0005
R461 vss.n5 vss.n193 17.0005
R462 vss.n5 vss.n194 17.0005
R463 vss.n5 vss.n195 17.0005
R464 vss.n5 vss.n196 17.0005
R465 vss.n5 vss.n197 17.0005
R466 vss.n5 vss.n198 17.0005
R467 vss.n5 vss.n199 17.0005
R468 vss.n5 vss.n200 17.0005
R469 vss.n5 vss.n201 17.0005
R470 vss.n5 vss.n202 17.0005
R471 vss.n5 vss.n203 17.0005
R472 vss.n5 vss.n204 17.0005
R473 vss.n5 vss.n205 17.0005
R474 vss.n5 vss.n206 17.0005
R475 vss.n5 vss.n207 17.0005
R476 vss.n5 vss.n208 17.0005
R477 vss.n5 vss.n209 17.0005
R478 vss.n5 vss.n210 17.0005
R479 vss.n5 vss.n211 17.0005
R480 vss.n5 vss.n212 17.0005
R481 vss.n5 vss.n213 17.0005
R482 vss.n5 vss.n214 17.0005
R483 vss.n23 vss.n147 8.49933
R484 vss.n123 vss.n23 8.49076
R485 vss.n124 vss.n23 8.491
R486 vss.n125 vss.n23 8.49124
R487 vss.n126 vss.n23 8.49738
R488 vss.n127 vss.n23 8.49148
R489 vss.n128 vss.n23 8.49172
R490 vss.n129 vss.n23 8.49196
R491 vss.n130 vss.n23 8.4922
R492 vss.n131 vss.n23 8.49244
R493 vss.n132 vss.n23 8.49268
R494 vss.n133 vss.n23 8.49908
R495 vss.n134 vss.n23 8.49292
R496 vss.n135 vss.n23 8.49316
R497 vss.n136 vss.n23 8.49341
R498 vss.n137 vss.n23 8.49365
R499 vss.n138 vss.n23 8.49389
R500 vss.n139 vss.n23 8.49414
R501 vss.n140 vss.n23 8.49438
R502 vss.n141 vss.n23 8.49463
R503 vss.n142 vss.n23 8.49487
R504 vss.n143 vss.n23 8.49512
R505 vss.n144 vss.n23 8.49537
R506 vss.n145 vss.n23 8.49561
R507 vss.n146 vss.n23 8.49586
R508 vss.n148 vss.n23 8.4961
R509 vss.n149 vss.n23 8.49635
R510 vss.n150 vss.n23 8.4966
R511 vss.n151 vss.n23 8.49685
R512 vss.n152 vss.n23 8.49709
R513 vss.n153 vss.n23 8.49734
R514 vss.n154 vss.n23 8.49759
R515 vss.n155 vss.n23 8.50175
R516 vss.n156 vss.n23 8.49784
R517 vss.n157 vss.n23 8.49809
R518 vss.n158 vss.n23 8.49834
R519 vss.n381 vss.n315 17.0005
R520 vss.n381 vss.n311 17.0005
R521 vss.n310 vss.t84 17.0005
R522 vss.t82 vss.t40 17.0005
R523 vss.t92 vss.t90 17.0005
R524 vss.n314 vss.t39 17.0005
R525 vss.t21 vss.n27 4.24098
R526 vss.t21 vss.t78 17.0005
R527 vss.t80 vss.t81 17.0005
R528 vss.t97 vss.t23 17.0005
R529 vss.t102 vss.t100 17.0005
R530 vss.t77 vss.t75 17.0005
R531 vss.n344 vss.t14 17.0005
R532 vss.t74 vss.t71 17.0005
R533 vss.n393 vss.t73 17.0005
R534 vss.t50 vss.n37 16.6364
R535 vss.n234 vss.t79 16.6364
R536 vss.n374 vss.n212 15.7416
R537 vss.n363 vss.t65 14.8603
R538 vss.t34 vss.n20 11.5701
R539 vss.n378 vss.t17 14.4299
R540 vss.n257 vss.n44 13.8637
R541 vss.n256 vss.n76 13.8637
R542 vss.n255 vss.n45 13.8637
R543 vss.n254 vss.n75 13.8637
R544 vss.n250 vss.n46 13.8637
R545 vss.n249 vss.n74 13.8637
R546 vss.n248 vss.n47 13.8637
R547 vss.n247 vss.n73 13.8637
R548 vss.n246 vss.n48 13.8637
R549 vss.n245 vss.n72 13.8637
R550 vss.n244 vss.n49 13.8637
R551 vss.n243 vss.n71 13.8637
R552 vss.n242 vss.n50 13.8637
R553 vss.n241 vss.n70 13.8637
R554 vss.n240 vss.n51 13.8637
R555 vss.n239 vss.n69 13.8637
R556 vss.n238 vss.n52 13.8637
R557 vss.n237 vss.n68 13.8637
R558 vss.n236 vss.n53 13.8637
R559 vss.n235 vss.n67 13.8637
R560 vss.n234 vss.n54 13.8637
R561 vss.n233 vss.n66 13.8637
R562 vss.n232 vss.n55 13.8637
R563 vss.n231 vss.n65 13.8637
R564 vss.n230 vss.n56 13.8637
R565 vss.n229 vss.n64 13.8637
R566 vss.n228 vss.n57 13.8637
R567 vss.n227 vss.n63 13.8637
R568 vss.n226 vss.n58 13.8637
R569 vss.n225 vss.n62 13.8637
R570 vss.n224 vss.n59 13.8637
R571 vss.n223 vss.n61 13.8637
R572 vss.n369 vss.t68 13.188
R573 vss.n366 vss.t49 13.188
R574 vss.t44 vss.n207 13.1181
R575 vss.t88 vss.n60 12.4774
R576 vss.t103 vss.n94 11.8064
R577 vss.n372 vss.n371 11.4754
R578 vss.n140 vss.n104 10.4946
R579 vss.n139 vss.n105 10.4946
R580 vss.n138 vss.n106 10.4946
R581 vss.n137 vss.n107 10.4946
R582 vss.n136 vss.n108 10.4946
R583 vss.n135 vss.n109 10.4946
R584 vss.n134 vss.n110 10.4946
R585 vss.n133 vss.n111 10.4946
R586 vss.n132 vss.n112 10.4946
R587 vss.n131 vss.n113 10.4946
R588 vss.n130 vss.n114 10.4946
R589 vss.n129 vss.n115 10.4946
R590 vss.n128 vss.n116 10.4946
R591 vss.n127 vss.n117 10.4946
R592 vss.n125 vss.n119 10.4946
R593 vss.n124 vss.n120 10.4946
R594 vss.n123 vss.n121 10.4946
R595 vss.n159 vss.n122 10.4946
R596 vss.n381 vss.n380 8.5005
R597 vss.n381 vss.n284 8.5005
R598 vss.n381 vss.n340 8.5005
R599 vss.n381 vss.n285 8.5005
R600 vss.n381 vss.n337 8.5005
R601 vss.n381 vss.n286 8.5005
R602 vss.n381 vss.n336 8.5005
R603 vss.n381 vss.n287 8.5005
R604 vss.n381 vss.n335 8.5005
R605 vss.n381 vss.n375 8.5005
R606 vss.n381 vss.n377 8.5005
R607 vss.n381 vss.n378 8.5005
R608 vss.n381 vss.n379 8.5005
R609 vss.n381 vss.n376 8.5005
R610 vss.n384 vss.n383 8.5005
R611 vss.n383 vss.n223 8.5005
R612 vss.n383 vss.n224 8.5005
R613 vss.n383 vss.n225 8.5005
R614 vss.n383 vss.n226 8.5005
R615 vss.n383 vss.n227 8.5005
R616 vss.n383 vss.n228 8.5005
R617 vss.n383 vss.n229 8.5005
R618 vss.n383 vss.n230 8.5005
R619 vss.n383 vss.n231 8.5005
R620 vss.n383 vss.n232 8.5005
R621 vss.n383 vss.n233 8.5005
R622 vss.n383 vss.n234 8.5005
R623 vss.n383 vss.n235 8.5005
R624 vss.n383 vss.n236 8.5005
R625 vss.n383 vss.n237 8.5005
R626 vss.n383 vss.n238 8.5005
R627 vss.n383 vss.n239 8.5005
R628 vss.n383 vss.n240 8.5005
R629 vss.n383 vss.n241 8.5005
R630 vss.n383 vss.n242 8.5005
R631 vss.n383 vss.n243 8.5005
R632 vss.n383 vss.n244 8.5005
R633 vss.n383 vss.n245 8.5005
R634 vss.n383 vss.n246 8.5005
R635 vss.n383 vss.n247 8.5005
R636 vss.n383 vss.n248 8.5005
R637 vss.n383 vss.n249 8.5005
R638 vss.n383 vss.n250 8.5005
R639 vss.n383 vss.n254 8.5005
R640 vss.n383 vss.n255 8.5005
R641 vss.n383 vss.n256 8.5005
R642 vss.n383 vss.n257 8.5005
R643 vss.n383 vss.n258 8.5005
R644 vss.n383 vss.n259 8.5005
R645 vss.n383 vss.n260 8.5005
R646 vss.n383 vss.n261 8.5005
R647 vss.n383 vss.n262 8.5005
R648 vss.n383 vss.n263 8.5005
R649 vss.n383 vss.n264 8.5005
R650 vss.n383 vss.n265 8.5005
R651 vss.n383 vss.n266 8.5005
R652 vss.n383 vss.n267 8.5005
R653 vss.n383 vss.n268 8.5005
R654 vss.n383 vss.n269 8.5005
R655 vss.n383 vss.n270 8.5005
R656 vss.n383 vss.n271 8.5005
R657 vss.n383 vss.n272 8.5005
R658 vss.n383 vss.n273 8.5005
R659 vss.n383 vss.n274 8.5005
R660 vss.n383 vss.n275 8.5005
R661 vss.n383 vss.n276 8.5005
R662 vss.n383 vss.n277 8.5005
R663 vss.n381 vss.n288 8.5005
R664 vss.n381 vss.n334 8.5005
R665 vss.n381 vss.n289 8.5005
R666 vss.n381 vss.n333 8.5005
R667 vss.n381 vss.n290 8.5005
R668 vss.n381 vss.n332 8.5005
R669 vss.n381 vss.n291 8.5005
R670 vss.n381 vss.n331 8.5005
R671 vss.n381 vss.n292 8.5005
R672 vss.n381 vss.n330 8.5005
R673 vss.n381 vss.n293 8.5005
R674 vss.n381 vss.n329 8.5005
R675 vss.n381 vss.n294 8.5005
R676 vss.n381 vss.n328 8.5005
R677 vss.n381 vss.n295 8.5005
R678 vss.n381 vss.n327 8.5005
R679 vss.n381 vss.n296 8.5005
R680 vss.n381 vss.n326 8.5005
R681 vss.n381 vss.n297 8.5005
R682 vss.n381 vss.n325 8.5005
R683 vss.n381 vss.n298 8.5005
R684 vss.n381 vss.n324 8.5005
R685 vss.n381 vss.n299 8.5005
R686 vss.n381 vss.n323 8.5005
R687 vss.n381 vss.n300 8.5005
R688 vss.n381 vss.n322 8.5005
R689 vss.n381 vss.n301 8.5005
R690 vss.n381 vss.n321 8.5005
R691 vss.n381 vss.n302 8.5005
R692 vss.n381 vss.n320 8.5005
R693 vss.n381 vss.n303 8.5005
R694 vss.n381 vss.n319 8.5005
R695 vss.n381 vss.n304 8.5005
R696 vss.n381 vss.n318 8.5005
R697 vss.n381 vss.n305 8.5005
R698 vss.n381 vss.n317 8.5005
R699 vss.n381 vss.n306 8.5005
R700 vss.n381 vss.n316 8.5005
R701 vss.n381 vss.n307 8.5005
R702 vss.t21 vss.n358 8.49188
R703 vss.n357 vss.t7 8.49188
R704 vss.t99 vss.n348 8.49188
R705 vss.n347 vss.t23 8.49188
R706 vss.n353 vss.t33 8.49188
R707 vss.t102 vss.n352 8.49188
R708 vss.n359 vss.t7 8.49176
R709 vss.t99 vss.n346 8.49176
R710 vss.t33 vss.n351 8.49176
R711 vss.t9 vss.n8 3.42543
R712 vss.n9 vss.n8 0.0620578
R713 vss.n343 vss.t77 8.49087
R714 vss.n342 vss.t14 8.49087
R715 vss.n392 vss.t74 8.49087
R716 vss.n391 vss.t73 8.49087
R717 vss.t9 vss.n356 8.49074
R718 vss.t45 vss.n282 8.48783
R719 vss.t52 vss.n281 8.48783
R720 vss.n279 vss.t48 8.48783
R721 vss.n278 vss.t51 8.48783
R722 vss.t57 vss.n220 8.48783
R723 vss.t89 vss.n219 8.48783
R724 vss.n216 vss.t60 8.48783
R725 vss.n215 vss.t96 8.48783
R726 vss.t84 vss.n309 8.48783
R727 vss.t40 vss.n308 8.48783
R728 vss.n313 vss.t92 8.48783
R729 vss.n312 vss.t39 8.48783
R730 vss.n24 vss.n23 0.0030318
R731 vss.t41 vss.n181 7.87107
R732 vss.t3 vss.n118 6.55931
R733 vss.n327 vss.t13 6.55931
R734 vss.n349 vss.t99 5.68329
R735 vss.n354 vss.t33 5.68329
R736 vss.n27 vss.t7 5.6831
R737 vss.n8 vss.t81 2.81683
R738 vss.n159 vss.n23 1.06159
R739 vss.t53 vss.n77 5.54579
R740 vss.t76 vss.n177 5.24755
R741 vss.t35 vss.n9 4.4755
R742 vss.t25 vss.n350 4.4755
R743 vss.t28 vss.n355 4.4755
R744 vss.n29 vss.n345 4.4755
R745 vss.t105 vss.n394 4.4755
R746 vss.t14 vss.n341 4.25206
R747 vss.t73 vss.n390 4.25206
R748 vss.t77 vss.n341 4.25175
R749 vss.t74 vss.n390 4.25175
R750 vss.n349 vss.t23 4.24047
R751 vss.n354 vss.t102 4.24047
R752 vss.n360 vss.n28 4.1005
R753 vss.n156 vss.t2 3.93579
R754 vss.n126 vss.t3 3.93579
R755 vss.n289 vss.t15 3.93579
R756 vss.t43 vss.n194 2.62402
R757 vss.n5 vss.n103 2.34678
R758 vss.n5 vss.n160 2.34678
R759 vss.n5 vss.n161 2.34678
R760 vss.n15 vss.n13 2.27125
R761 vss.n339 vss.t16 2.26086
R762 vss.n5 vss.n18 0.585902
R763 vss.n372 vss.n5 1.36272
R764 vss.n16 vss.n5 0.943819
R765 vss.n5 vss.t28 1.73138
R766 vss.n381 vss.n361 0.986957
R767 vss.n253 vss.t54 0.725985
R768 vss.t54 vss.n251 0.718957
R769 vss.t42 vss.n338 0.715539
R770 vss.n339 vss.t42 0.676742
R771 vss.n5 vss.n3 0.331038
R772 vss.t35 vss.t25 0.309901
R773 vss.n19 vss.t88 96.4067
R774 vss.n5 vss.n1 0.060606
R775 vss.n361 vss.n339 0.253688
R776 vss.n361 vss.n253 0.243936
R777 vss.n29 vss.t105 0.231286
R778 vss.t16 vss.n360 0.135543
R779 vss.n370 vss.n5 0.120581
R780 vss.n368 vss.n5 0.120581
R781 vss.n365 vss.n5 0.120581
R782 vss.n364 vss.n5 0.120581
R783 vss.n362 vss.n5 0.120581
R784 vss.n20 vss.n5 0.0408726
R785 vss.n367 vss.n5 0.116916
R786 vss.n252 vss.n280 0.0899444
R787 vss.n382 vss.n283 0.0899444
R788 vss.n218 vss.n217 0.0899444
R789 vss.n222 vss.n221 0.0899444
R790 vss.n315 vss.n314 0.0899444
R791 vss.n311 vss.n310 0.0899444
R792 vss.t25 vss.t28 0.0835571
R793 vss.t16 vss.n29 0.0654286
R794 vss.n28 vss.n27 0.0444465
R795 vss.n279 vss.n278 0.054196
R796 vss.n282 vss.n281 0.054196
R797 vss.n216 vss.n215 0.054196
R798 vss.n220 vss.n219 0.054196
R799 vss.n313 vss.n312 0.054196
R800 vss.n309 vss.n308 0.054196
R801 vss.n360 vss.t35 0.0533429
R802 vss.n5 vss.n4 0.0475125
R803 vss.n5 vss.n2 0.0396081
R804 vss.n350 vss.n349 0.0448653
R805 vss.n355 vss.n354 0.0448653
R806 vss.n356 vss.n9 0.0422843
R807 vss.n5 vss.n15 4.76469
R808 vss.n343 vss.n342 0.0420072
R809 vss.n392 vss.n391 0.0420072
R810 vss.n345 vss.n344 0.0410556
R811 vss.n394 vss.n393 0.0410556
R812 vss.n381 vss.t42 0.0383438
R813 vss.n345 vss.n341 0.0382434
R814 vss.n394 vss.n390 0.0382434
R815 vss.n359 vss.n358 0.0382103
R816 vss.n347 vss.n346 0.0382103
R817 vss.n352 vss.n351 0.0382103
R818 vss.n358 vss.n357 0.0379609
R819 vss.n348 vss.n347 0.0379609
R820 vss.n353 vss.n352 0.0379609
R821 vss.n369 vss.n5 0.0365679
R822 vss.n366 vss.n5 0.0365679
R823 vss.n363 vss.n5 0.0365679
R824 vss.n5 vss.n0 0.0363214
R825 vss.n282 vss.t85 0.027348
R826 vss.n280 vss.n279 0.027348
R827 vss.t93 vss.n278 0.027348
R828 vss.n283 vss.n281 0.027348
R829 vss.n220 vss.t87 0.027348
R830 vss.n221 vss.n219 0.027348
R831 vss.n217 vss.n216 0.027348
R832 vss.t95 vss.n215 0.027348
R833 vss.n309 vss.t82 0.027348
R834 vss.n314 vss.n313 0.027348
R835 vss.t90 vss.n312 0.027348
R836 vss.n310 vss.n308 0.027348
R837 vss.n356 vss.t80 0.0215307
R838 vss.n344 vss.n343 0.0212536
R839 vss.t75 vss.n342 0.0212536
R840 vss.n393 vss.n392 0.0212536
R841 vss.t71 vss.n391 0.0212536
R842 vss.n357 vss.n28 0.0197304
R843 vss.n383 vss.t54 0.0195241
R844 vss.t78 vss.n359 0.0194799
R845 vss.n350 vss.n346 0.0194799
R846 vss.n355 vss.n351 0.0194799
R847 vss.n253 vss.n252 0.0193889
R848 vss.n382 vss.n253 0.0193889
R849 vss.n251 vss.n218 0.0193889
R850 vss.n251 vss.n222 0.0193889
R851 vss.n338 vss.n315 0.0193889
R852 vss.n338 vss.n311 0.0193889
R853 vss.n348 vss.t97 0.0192304
R854 vss.t100 vss.n353 0.0192304
R855 vss.n33 vss.n30 0.0160592
R856 vss.n13 vss.n12 0.00877605
R857 vss.n387 vss.n386 0.0160592
R858 vss.n32 vss.n31 0.0160592
R859 vss.n389 vss.n388 0.0160592
R860 vss.n16 vss.n26 0.025099
R861 vss.n33 vss.n25 0.0223398
R862 vss.n30 vss.n12 0.0178221
R863 vss.n387 vss.n14 0.0223398
R864 vss.n386 vss.n32 0.00954605
R865 vss.n388 vss.n31 0.00954605
R866 vss.n389 vss.n26 0.00954605
R867 vss.n24 vss.n16 1.41145
R868 vss.t105 vss.n15 0.00954286
R869 vss.n11 vss.n24 1.38976
C0 a_12967_4979# a_12967_4615# 0.41855f
C1 inn a_6733_6167# 0.05682f
C2 a_3520_5051# a_592_286# 0.50926f
C3 a_1076_5541# out 2.63791f
C4 a_14767_4615# a_12967_4615# 0.03876f
C5 a_1076_5541# a_14767_2795# 0.08835f
C6 a_1076_5541# a_12967_4979# 0.04703f
C7 a_4818_4945# a_3520_5051# 1.41489f
C8 a_1076_5541# a_9288_5041# 6.12937f
C9 a_592_286# a_9508_346# 0.04713f
C10 a_6733_6167# vdd 4.07099f
C11 a_1076_5541# a_12967_3159# 0.02269f
C12 a_12881_4251# w_8388_2366# 0.05972f
C13 a_14767_4615# a_1076_5541# 0.0425f
C14 inn a_8488_4945# 1.61325f
C15 a_12881_3523# a_12967_3887# 0.03876f
C16 a_1076_5541# inp 0.90904f
C17 inn a_592_286# 0.18652f
C18 a_1076_5541# a_442_5111# 0.36499f
C19 a_12881_2795# a_12967_3159# 0.03876f
C20 a_4818_4945# inn 0.02908f
C21 a_9288_5041# a_6733_6167# 0.68398f
C22 a_1076_5541# w_8388_2366# 0.19433f
C23 vdd a_592_286# 40.1816f
C24 a_6733_6167# inp 0.05113f
C25 a_9288_5041# a_11355_6131# 0.08475f
C26 inn a_3520_5051# 0.41738f
C27 a_4818_4945# vdd 0.17875f
C28 a_442_5111# a_6733_6167# 0.02761f
C29 a_12967_5343# a_14767_5343# 0.08145f
C30 a_1076_5541# a_1392_382# 3.32729f
C31 w_8388_2366# a_12881_2795# 0.06123f
C32 a_9288_5041# a_8488_4945# 1.61235f
C33 w_8388_2366# a_6733_6167# 0.45082f
C34 a_3520_5051# vdd 21.1602f
C35 a_8488_4945# inp 0.75053f
C36 a_592_286# inp 0.70839f
C37 a_12967_3887# a_12967_4251# 0.41855f
C38 a_9288_5041# a_12881_3523# 0.02692f
C39 a_1076_5541# a_592_2733# 4.22191f
C40 a_1076_5541# a_5933_6071# 0.13572f
C41 a_592_286# ibias 0.91726f
C42 a_442_5111# a_592_286# 0.98287f
C43 a_6733_6167# a_1392_382# 1.19197f
C44 w_8388_2366# a_8488_4945# 2.35714f
C45 vdd a_9508_346# 3.10128f
C46 a_12967_5343# a_12967_4979# 0.41855f
C47 a_4818_4945# inp 0.23197f
C48 w_8388_2366# a_592_286# 3.79753f
C49 a_11355_6131# a_1392_382# 0.86368f
C50 a_4818_4945# ibias 0.79005f
C51 a_4818_4945# a_442_5111# 1.13966f
C52 a_14767_5343# a_12967_4251# 0.01305f
C53 inn vdd 0.32651f
C54 a_12881_4979# a_12881_4251# 0.03326f
C55 a_3520_5051# inp 0.11636f
C56 w_8388_2366# a_12881_3523# 0.06745f
C57 a_5933_6071# a_6733_6167# 3.75055f
C58 a_4818_4945# w_8388_2366# 0.8752f
C59 a_8488_4945# a_1392_382# 0.50009f
C60 a_3520_5051# ibias 0.03463f
C61 a_9288_5041# a_12967_3887# 0.17703f
C62 a_1392_382# a_592_286# 2.02273f
C63 a_442_5111# a_3520_5051# 0.69581f
C64 a_12967_2795# a_12967_2431# 0.41855f
C65 out a_14767_5343# 0.64741p
C66 a_12881_4979# a_1076_5541# 0.02632f
C67 w_8388_2366# a_3520_5051# 2.0083f
C68 inp a_9508_346# 0.01462f
C69 a_9288_5041# inn 0.38814f
C70 a_14767_5343# a_12967_4979# 0.04329f
C71 a_5933_6071# a_8488_4945# 2.64181f
C72 out vdd 3.65864f
C73 a_9288_5041# a_14767_5343# 0.05644f
C74 inn inp 9.25705f
C75 a_592_2733# a_592_286# 0.76593f
C76 a_12967_3523# a_1076_5541# 0.02011f
C77 a_14767_2795# vdd 0.39326f
C78 a_9288_5041# a_12967_4251# 0.01473f
C79 a_14767_3159# a_14767_2795# 0.16843f
C80 a_5933_6071# a_592_286# 1.27339f
C81 a_14767_4615# a_14767_5343# 0.16869f
C82 inn ibias 0.2049f
C83 a_12881_4251# a_12967_4615# 0.03876f
C84 inn a_442_5111# 1.17952f
C85 w_8388_2366# a_9508_346# 0.01539f
C86 a_1076_5541# a_12967_2431# 0.18758f
C87 a_3520_5051# a_1392_382# 0.18479f
C88 a_9288_5041# vdd 0.73866f
C89 a_14767_3159# a_9288_5041# 0.04336f
C90 a_14767_3159# a_12967_3159# 0.03876f
C91 out a_14767_2795# 0.65052p
C92 a_4818_4945# a_5933_6071# 2.09172f
C93 inn w_8388_2366# 6.57353f
C94 a_1076_5541# a_12967_2795# 0.02684f
C95 vdd inp 0.12827f
C96 a_12881_4251# a_1076_5541# 0.04323f
C97 a_9288_5041# out 1.55499f
C98 vdd ibias 0.01131f
C99 a_442_5111# vdd 0.03721f
C100 a_9288_5041# a_14767_2795# 1.6495f
C101 a_1076_5541# a_12967_4615# 0.06311f
C102 a_14767_2795# a_12967_3159# 0.04329f
C103 a_592_2733# a_3520_5051# 0.13572f
C104 a_14767_4615# a_12967_4979# 0.03876f
C105 inn a_1392_382# 0.24563f
C106 a_12967_5343# a_12967_5707# 0.41855f
C107 w_8388_2366# vdd 1.96252f
C108 a_9288_5041# a_12967_3159# 0.04099f
C109 a_12967_2795# a_12881_2795# 0.03876f
C110 a_9288_5041# inp 1.78837f
C111 vdd a_1392_382# 2.45934f
C112 inn a_592_2733# 1.85441f
C113 a_5933_6071# inn 0.02775f
C114 ibias inp 0.23792f
C115 a_9288_5041# w_8388_2366# 1.361f
C116 a_442_5111# inp 1.12371f
C117 a_1076_5541# a_12881_2795# 0.02347f
C118 a_442_5111# ibias 0.91398f
C119 a_12967_3523# a_12881_3523# 0.03876f
C120 a_12881_4979# a_12967_5343# 0.03876f
C121 a_1076_5541# a_6733_6167# 2.41377f
C122 w_8388_2366# inp 6.56275f
C123 a_14767_5343# a_12967_5707# 0.04289f
C124 a_592_2733# vdd 20.6876f
C125 a_5933_6071# vdd 1.13002f
C126 w_8388_2366# a_442_5111# 0.03827f
C127 a_9288_5041# a_1392_382# 1.84178f
C128 a_12881_4251# a_12881_3523# 0.03326f
C129 a_1392_382# inp 0.28632f
C130 a_1076_5541# a_592_286# 2.49079f
C131 a_12967_3523# a_12967_3887# 0.41855f
C132 a_9288_5041# a_5933_6071# 0.65266f
C133 w_8388_2366# a_1392_382# 1.39908f
C134 a_9288_5041# a_12967_5707# 0.04055f
C135 a_1076_5541# a_12881_3523# 0.02244f
C136 a_592_2733# inp 0.40598f
C137 a_5933_6071# inp 0.07667f
C138 a_592_2733# ibias 0.06899f
C139 a_592_2733# a_442_5111# 0.47279f
C140 a_5933_6071# a_442_5111# 0.06572f
C141 a_6733_6167# a_592_286# 0.09188f
C142 a_12967_5343# a_1076_5541# 0.04008f
C143 a_1076_5541# a_3520_5051# 0.22008f
C144 a_11355_6131# a_8488_4945# 0.09158f
C145 a_5933_6071# w_8388_2366# 0.47568f
C146 a_12881_3523# a_12881_2795# 0.03326f
C147 a_12967_3523# a_14767_3159# 0.03876f
C148 a_4818_4945# a_6733_6167# 0.34486f
C149 vdd a_12967_2431# 0.01212f
C150 a_12881_4979# a_12967_4979# 0.03876f
C151 a_1076_5541# a_12967_3887# 0.03091f
C152 a_12881_4251# a_12967_4251# 0.03876f
C153 a_1076_5541# a_9508_346# 0.0855f
C154 a_592_2733# a_1392_382# 0.08807f
C155 a_8488_4945# a_592_286# 0.13221f
C156 a_14767_5343# a_12967_4615# 0.04329f
C157 a_12967_3523# a_14767_2795# 0.04329f
C158 a_5933_6071# a_1392_382# 0.08186f
C159 a_12967_4615# a_12967_4251# 0.41855f
C160 a_6733_6167# a_3520_5051# 0.14525f
C161 a_1076_5541# inn 0.53027f
C162 a_12967_5707# a_1392_382# 0.11367f
C163 a_14767_2795# a_12967_2431# 0.0255f
C164 a_12967_3523# a_9288_5041# 0.05266f
C165 a_12967_3523# a_12967_3159# 0.41855f
C166 a_4818_4945# a_8488_4945# 0.49789f
C167 a_1076_5541# a_14767_5343# 0.1561f
C168 a_9288_5041# a_12967_2431# 0.01328f
C169 a_12967_2795# a_14767_2795# 0.08145f
C170 a_4818_4945# a_592_286# 0.61037f
C171 a_1076_5541# a_12967_4251# 0.19604f
C172 a_6733_6167# a_9508_346# 1.48569f
C173 a_9288_5041# a_12967_2795# 0.04495f
C174 a_1076_5541# vdd 18.0695f
C175 a_12967_2795# a_12967_3159# 0.41855f
C176 out 0 0.10717p
C177 a_14767_2795# 0 14.31952f
C178 a_12881_2795# 0 1.7144f
C179 a_14767_3159# 0 1.63674f
C180 a_12881_3523# 0 1.6197f
C181 a_12881_4251# 0 1.62754f
C182 a_14767_4615# 0 1.64562f
C183 a_14767_5343# 0 15.60814f
C184 a_12881_4979# 0 1.7931f
C185 vss.t54 0 1.21982f
C186 vss.t51 0 6.0676f
C187 vss.t42 0 6.58385f
C188 vss.t77 0 7.34755f
C189 vss.t25 0 7.05264f
C190 vss.t35 0 2.10688f
C191 vss.t23 0 0.32334f
C192 vss.t28 0 6.73836f
C193 vss.t7 0 2.98924f
C194 vss.t16 0 6.41115f
C195 out.t0 0 1.08192p
C196 out.t1 0 6.48473f
C197 out.t2 0 2.64818f
C198 out.t3 0 0.15563p
.ends
