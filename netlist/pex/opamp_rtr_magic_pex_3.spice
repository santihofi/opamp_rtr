* PEX produced on Mon Sep 14 09:19:54 AM CEST 2026 using /foss/tools/sak/sak-pex.sh with m=3 and s=1 (extresist threshold=10000 mOhm, minres=1000 mOhm, mindelay=1 ps)
* NGSPICE file created from opamp_rtr_pex.ext - technology: ihp-sg13cmos5l

.subckt opamp_rtr_pex vdd inp vss inn ibias out
X0 out.t0 a_9288_5041# vss.t28 vss.t31 sg13_hv_nmos ad=0.475p pd=2.88u as=0.475p ps=2.88u w=2.5u l=1u
X1 vdd a_592_286# a_1392_382# vdd sg13_hv_pmos ad=1.425p pd=7.88u as=1.425p ps=7.88u w=7.5u l=4u
X2 w_8388_2366# w_8388_2366# w_8388_2366# w_8388_2366# sg13_hv_pmos ad=0.7125p pd=4.13u as=62.7835p ps=0.25869m w=3.75u l=0.4u
X3 vss.t77 ibias a_442_5111# vss.t109 sg13_hv_nmos ad=0.475p pd=2.88u as=0.475p ps=2.88u w=2.5u l=4u
X4 a_442_5111# a_442_5111# a_442_5111# vss.t3 sg13_hv_nmos ad=0.2375p pd=1.63u as=13.7666p ps=96.82u w=1.25u l=0.45u
X5 out a_1076_5541# vdd vdd sg13_hv_pmos ad=1.425p pd=7.88u as=1.425p ps=7.88u w=7.5u l=1u
X6 vss.t99 vss.t97 vss.t23 vss.t98 sg13_hv_nmos ad=0.85p pd=5.68u as=0 ps=0 w=2.5u l=0.45u
X7 ibias ibias vss.t105 vss.t107 sg13_hv_nmos ad=0.475p pd=2.88u as=0.475p ps=2.88u w=2.5u l=4u
X8 vdd vdd vdd vdd sg13_hv_pmos ad=0.7125p pd=4.13u as=0.18065n ps=0.47106m w=3.75u l=0.4u
X9 w_8388_2366# a_592_286# vdd vdd sg13_hv_pmos ad=1.425p pd=7.88u as=1.425p ps=7.88u w=7.5u l=4u
X10 a_9288_5041# inp w_8388_2366# w_8388_2366# sg13_hv_pmos ad=0.7125p pd=4.13u as=0.7125p ps=4.13u w=3.75u l=2u
X11 a_9288_5041# a_8488_4945# vss.t51 vss.t50 sg13_hv_nmos ad=0.2375p pd=1.63u as=0.2375p ps=1.63u w=1.25u l=4u
X12 a_592_2733# a_592_2733# vdd vdd sg13_hv_pmos ad=0.7125p pd=4.13u as=0.7125p ps=4.13u w=3.75u l=4u
X13 a_442_5111# a_442_5111# a_442_5111# vss.t5 sg13_hv_nmos ad=0.475p pd=2.88u as=0 ps=0 w=2.5u l=0.45u
X14 w_8388_2366# inn a_8488_4945# w_8388_2366# sg13_hv_pmos ad=0.7125p pd=4.13u as=0.7125p ps=4.13u w=3.75u l=2u
X15 w_8388_2366# a_3520_5051# vdd vdd sg13_hv_pmos ad=0.7125p pd=4.13u as=0.7125p ps=4.13u w=3.75u l=4u
X16 out.t1 a_9288_5041# vss.t25 vss.t26 sg13_hv_nmos ad=0.475p pd=2.88u as=0.475p ps=2.88u w=2.5u l=1u
X17 a_592_2733# inn a_442_5111# vss.t63 sg13_hv_nmos ad=0.2375p pd=1.63u as=0.2375p ps=1.63u w=1.25u l=2u
X18 a_12881_4979# a_14767_4615# vss.t65 rhigh l=9u w=1u
X19 w_8388_2366# w_8388_2366# w_8388_2366# w_8388_2366# sg13_hv_pmos ad=2.55p pd=15.68u as=0 ps=0 w=7.5u l=0.4u
X20 a_11355_6131# a_1392_382# a_1392_382# vss.t11 sg13_hv_nmos ad=0.475p pd=2.88u as=0.475p ps=2.88u w=2.5u l=1u
X21 a_442_5111# a_4818_4945# vss.t42 vss.t43 sg13_hv_nmos ad=0.2375p pd=1.63u as=0.2375p ps=1.63u w=1.25u l=4u
X22 a_8488_4945# inn w_8388_2366# w_8388_2366# sg13_hv_pmos ad=0.7125p pd=4.13u as=0.7125p ps=4.13u w=3.75u l=2u
X23 vss.t84 vss.t82 vss.t40 vss.t83 sg13_hv_nmos ad=0.425p pd=3.18u as=0 ps=0 w=1.25u l=0.45u
X24 vss.t35 vss.t35 vss.t34 rhigh l=9u w=1u
X25 a_1076_5541# a_592_2733# vdd vdd sg13_hv_pmos ad=0.7125p pd=4.13u as=0.7125p ps=4.13u w=3.75u l=4u
X26 vss.t21 vss.t78 vss.t7 vss.t79 sg13_hv_nmos ad=0.475p pd=2.88u as=0 ps=0 w=2.5u l=0.45u
X27 a_12881_4251# a_1076_5541# vss.t36 rhigh l=9u w=1u
X28 vdd vdd vdd vdd sg13_hv_pmos ad=1.275p pd=8.18u as=0 ps=0 w=3.75u l=0.4u
X29 a_9288_5041# a_8488_4945# vss.t54 vss.t55 sg13_hv_nmos ad=0.2375p pd=1.63u as=0.2375p ps=1.63u w=1.25u l=4u
X30 a_442_5111# a_592_286# a_3520_5051# vss.t1 sg13_hv_nmos ad=0.475p pd=2.88u as=0.475p ps=2.88u w=2.5u l=1u
X31 vss.t25 a_9288_5041# out.t1 vss.t24 sg13_hv_nmos ad=0.475p pd=2.88u as=0.475p ps=2.88u w=2.5u l=1u
X32 a_1076_5541# a_1076_5541# a_1076_5541# vdd sg13_hv_pmos ad=1.425p pd=7.88u as=34.7735p ps=0.10686m w=7.5u l=1u
X33 vdd a_592_286# a_5933_6071# vdd sg13_hv_pmos ad=1.425p pd=7.88u as=1.425p ps=7.88u w=7.5u l=4u
X34 a_12881_2795# a_14767_3159# vss.t70 rhigh l=9u w=1u
X35 a_442_5111# inn a_592_2733# vss.t62 sg13_hv_nmos ad=0.2375p pd=1.63u as=0.2375p ps=1.63u w=1.25u l=2u
X36 vdd a_1076_5541# out vdd sg13_hv_pmos ad=1.425p pd=7.88u as=1.425p ps=7.88u w=7.5u l=1u
X37 vss.t25 vss.t25 vss.t67 rhigh l=9u w=1u
X38 vss.t9 vss.t80 vss.t81 vss.t12 sg13_hv_nmos ad=0.475p pd=2.88u as=0 ps=0 w=2.5u l=0.45u
X39 vss.t105 ibias a_592_286# vss.t104 sg13_hv_nmos ad=0.475p pd=2.88u as=0.475p ps=2.88u w=2.5u l=4u
X40 vdd vdd vdd vdd sg13_hv_pmos ad=0.7125p pd=4.13u as=0 ps=0 w=3.75u l=0.4u
X41 vss.t16 a_5933_6071# a_5933_6071# vss.t18 sg13_hv_nmos ad=0.475p pd=2.88u as=0.475p ps=2.88u w=2.5u l=4u
X42 vdd a_592_2733# a_1076_5541# vdd sg13_hv_pmos ad=0.7125p pd=4.13u as=0.7125p ps=4.13u w=3.75u l=4u
X43 a_3520_5051# a_592_286# a_442_5111# vss.t0 sg13_hv_nmos ad=0.475p pd=2.88u as=0.475p ps=2.88u w=2.5u l=1u
X44 vdd a_592_2733# a_1076_5541# vdd sg13_hv_pmos ad=0.7125p pd=4.13u as=0.7125p ps=4.13u w=3.75u l=4u
X45 a_9508_346# a_9508_346# vdd vdd sg13_hv_pmos ad=1.425p pd=7.88u as=1.425p ps=7.88u w=7.5u l=1u
X46 vdd a_3520_5051# a_3520_5051# vdd sg13_hv_pmos ad=0.7125p pd=4.13u as=0.7125p ps=4.13u w=3.75u l=4u
X47 a_4818_4945# a_4818_4945# vss.t40 vss.t38 sg13_hv_nmos ad=0.2375p pd=1.63u as=0.2375p ps=1.63u w=1.25u l=4u
X48 a_442_5111# inp a_1076_5541# vss.t64 sg13_hv_nmos ad=0.2375p pd=1.63u as=0.2375p ps=1.63u w=1.25u l=2u
X49 vdd a_3520_5051# a_3520_5051# vdd sg13_hv_pmos ad=0.7125p pd=4.13u as=0.7125p ps=4.13u w=3.75u l=4u
X50 vdd vdd vdd vdd sg13_hv_pmos ad=2.55p pd=15.68u as=0 ps=0 w=7.5u l=0.4u
X51 vss.t42 a_4818_4945# a_4818_4945# vss.t41 sg13_hv_nmos ad=0.2375p pd=1.63u as=0.2375p ps=1.63u w=1.25u l=4u
X52 a_442_5111# ibias vss.t105 vss.t106 sg13_hv_nmos ad=0.475p pd=2.88u as=0.475p ps=2.88u w=2.5u l=4u
X53 w_8388_2366# a_3520_5051# vdd vdd sg13_hv_pmos ad=0.7125p pd=4.13u as=0.7125p ps=4.13u w=3.75u l=4u
X54 a_5933_6071# a_592_286# vdd vdd sg13_hv_pmos ad=1.425p pd=7.88u as=1.425p ps=7.88u w=7.5u l=4u
X55 a_1076_5541# a_592_286# vdd vdd sg13_hv_pmos ad=1.425p pd=7.88u as=1.425p ps=7.88u w=7.5u l=4u
X56 a_4818_4945# a_4818_4945# vss.t42 vss.t43 sg13_hv_nmos ad=0.2375p pd=1.63u as=0.2375p ps=1.63u w=1.25u l=4u
X57 a_442_5111# inp a_1076_5541# vss.t62 sg13_hv_nmos ad=0.2375p pd=1.63u as=0.2375p ps=1.63u w=1.25u l=2u
X58 vss.t92 vss.t90 vss.t39 vss.t83 sg13_hv_nmos ad=0.425p pd=3.18u as=0 ps=0 w=1.25u l=0.45u
X59 w_8388_2366# w_8388_2366# w_8388_2366# w_8388_2366# sg13_hv_pmos ad=0.7125p pd=4.13u as=0 ps=0 w=3.75u l=0.4u
X60 vss.t21 a_5933_6071# a_9288_5041# vss.t20 sg13_hv_nmos ad=0.475p pd=2.88u as=0.475p ps=2.88u w=2.5u l=4u
X61 vss.t57 vss.t87 vss.t89 vss.t88 sg13_hv_nmos ad=0.2375p pd=1.63u as=0 ps=0 w=1.25u l=0.45u
X62 vdd a_1076_5541# out vdd sg13_hv_pmos ad=1.425p pd=7.88u as=1.425p ps=7.88u w=7.5u l=1u
X63 vss.t45 vss.t85 vss.t52 vss.t86 sg13_hv_nmos ad=0.2375p pd=1.63u as=0 ps=0 w=1.25u l=0.45u
X64 a_9288_5041# a_9288_5041# a_9288_5041# vss.t12 sg13_hv_nmos ad=0.85p pd=5.68u as=17.3283p ps=85.93999u w=2.5u l=1u
X65 vdd vdd vdd vdd sg13_hv_pmos ad=1.425p pd=7.88u as=0 ps=0 w=7.5u l=0.4u
X66 a_9288_5041# a_9288_5041# a_9288_5041# vss.t12 sg13_hv_nmos ad=0.475p pd=2.88u as=0 ps=0 w=2.5u l=1u
X67 a_8488_4945# inn w_8388_2366# w_8388_2366# sg13_hv_pmos ad=0.7125p pd=4.13u as=0.7125p ps=4.13u w=3.75u l=2u
X68 a_8488_4945# a_8488_4945# vss.t54 vss.t55 sg13_hv_nmos ad=0.2375p pd=1.63u as=0.2375p ps=1.63u w=1.25u l=4u
X69 w_8388_2366# w_8388_2366# w_8388_2366# w_8388_2366# sg13_hv_pmos ad=1.275p pd=8.18u as=0 ps=0 w=3.75u l=0.4u
X70 vss.t74 vss.t71 vss.t73 vss.t72 sg13_hv_nmos ad=0.85p pd=5.68u as=0 ps=0 w=2.5u l=0.45u
X71 a_12881_3523# a_9288_5041# vss.t49 rhigh l=9u w=1u
X72 vdd a_592_286# a_1076_5541# vdd sg13_hv_pmos ad=1.425p pd=7.88u as=1.425p ps=7.88u w=7.5u l=4u
X73 a_592_2733# inn a_442_5111# vss.t61 sg13_hv_nmos ad=0.2375p pd=1.63u as=0.2375p ps=1.63u w=1.25u l=2u
X74 a_442_5111# inn a_592_2733# vss.t64 sg13_hv_nmos ad=0.2375p pd=1.63u as=0.2375p ps=1.63u w=1.25u l=2u
X75 a_1392_382# a_1392_382# a_11355_6131# vss.t10 sg13_hv_nmos ad=0.475p pd=2.88u as=0.475p ps=2.88u w=2.5u l=1u
X76 a_9288_5041# inp w_8388_2366# w_8388_2366# sg13_hv_pmos ad=0.7125p pd=4.13u as=0.7125p ps=4.13u w=3.75u l=2u
X77 vss.t16 a_5933_6071# a_6733_6167# vss.t15 sg13_hv_nmos ad=0.475p pd=2.88u as=0.475p ps=2.88u w=2.5u l=4u
X78 out.t1 a_9288_5041# vss.t23 vss.t22 sg13_hv_nmos ad=0.475p pd=2.88u as=0.475p ps=2.88u w=2.5u l=1u
X79 a_1076_5541# a_6733_6167# a_9288_5041# vdd sg13_hv_pmos ad=1.425p pd=7.88u as=1.425p ps=7.88u w=7.5u l=1u
X80 vdd a_9508_346# a_9508_346# vdd sg13_hv_pmos ad=1.425p pd=7.88u as=1.425p ps=7.88u w=7.5u l=1u
X81 a_12881_4251# a_14767_4615# vss.t66 rhigh l=9u w=1u
X82 a_5933_6071# a_5933_6071# vss.t16 vss.t17 sg13_hv_nmos ad=0.475p pd=2.88u as=0.475p ps=2.88u w=2.5u l=4u
X83 a_442_5111# a_442_5111# a_442_5111# vss.t2 sg13_hv_nmos ad=0.425p pd=3.18u as=0 ps=0 w=1.25u l=0.45u
X84 a_1076_5541# a_592_2733# vdd vdd sg13_hv_pmos ad=0.7125p pd=4.13u as=0.7125p ps=4.13u w=3.75u l=4u
X85 vss.t77 vss.t75 vss.t14 vss.t76 sg13_hv_nmos ad=0.475p pd=2.88u as=0 ps=0 w=2.5u l=0.45u
X86 vdd vdd vdd vdd sg13_hv_pmos ad=1.425p pd=7.88u as=0 ps=0 w=7.5u l=0.4u
X87 a_442_5111# a_4818_4945# vss.t39 vss.t38 sg13_hv_nmos ad=0.2375p pd=1.63u as=0.2375p ps=1.63u w=1.25u l=4u
X88 a_9508_346# a_6733_6167# a_6733_6167# vdd sg13_hv_pmos ad=1.425p pd=7.88u as=1.425p ps=7.88u w=7.5u l=1u
X89 vss.t105 ibias ibias vss.t108 sg13_hv_nmos ad=0.475p pd=2.88u as=0.475p ps=2.88u w=2.5u l=4u
X90 vss.t28 a_9288_5041# out.t1 vss.t30 sg13_hv_nmos ad=0.475p pd=2.88u as=0.475p ps=2.88u w=2.5u l=1u
X91 out a_1076_5541# vdd vdd sg13_hv_pmos ad=1.425p pd=7.88u as=1.425p ps=7.88u w=7.5u l=1u
X92 vss.t42 a_4818_4945# a_442_5111# vss.t41 sg13_hv_nmos ad=0.2375p pd=1.63u as=0.2375p ps=1.63u w=1.25u l=4u
X93 a_4818_4945# a_592_286# w_8388_2366# w_8388_2366# sg13_hv_pmos ad=1.425p pd=7.88u as=1.425p ps=7.88u w=7.5u l=1u
X94 a_11355_6131# a_11355_6131# vss.t7 vss.t6 sg13_hv_nmos ad=0.475p pd=2.88u as=0.475p ps=2.88u w=2.5u l=1u
X95 a_592_2733# a_592_2733# vdd vdd sg13_hv_pmos ad=0.7125p pd=4.13u as=0.7125p ps=4.13u w=3.75u l=4u
X96 vss.t9 a_11355_6131# a_11355_6131# vss.t8 sg13_hv_nmos ad=0.475p pd=2.88u as=0.475p ps=2.88u w=2.5u l=1u
X97 vss.t54 a_8488_4945# a_8488_4945# vss.t53 sg13_hv_nmos ad=0.2375p pd=1.63u as=0.2375p ps=1.63u w=1.25u l=4u
X98 a_9288_5041# a_6733_6167# a_1076_5541# vdd sg13_hv_pmos ad=1.425p pd=7.88u as=1.425p ps=7.88u w=7.5u l=1u
X99 vdd vdd vdd vdd sg13_hv_pmos ad=0.7125p pd=4.13u as=0 ps=0 w=3.75u l=0.4u
X100 vdd vdd vdd vdd sg13_hv_pmos ad=1.275p pd=8.18u as=0 ps=0 w=3.75u l=0.4u
X101 w_8388_2366# inn a_8488_4945# w_8388_2366# sg13_hv_pmos ad=0.7125p pd=4.13u as=0.7125p ps=4.13u w=3.75u l=2u
X102 vss.t45 a_4818_4945# a_442_5111# vss.t44 sg13_hv_nmos ad=0.2375p pd=1.63u as=0.2375p ps=1.63u w=1.25u l=4u
X103 a_1076_5541# inp a_442_5111# vss.t61 sg13_hv_nmos ad=0.2375p pd=1.63u as=0.2375p ps=1.63u w=1.25u l=2u
X104 vss.t60 vss.t95 vss.t96 vss.t88 sg13_hv_nmos ad=0.2375p pd=1.63u as=0 ps=0 w=1.25u l=0.45u
X105 a_1076_5541# a_1392_382# a_9288_5041# vss.t12 sg13_hv_nmos ad=0.475p pd=2.88u as=0.475p ps=2.88u w=2.5u l=1u
X106 a_3520_5051# a_3520_5051# vdd vdd sg13_hv_pmos ad=0.7125p pd=4.13u as=0.7125p ps=4.13u w=3.75u l=4u
X107 vss.t48 vss.t93 vss.t51 vss.t86 sg13_hv_nmos ad=0.2375p pd=1.63u as=0 ps=0 w=1.25u l=0.45u
X108 a_442_5111# a_442_5111# a_442_5111# vss.t2 sg13_hv_nmos ad=0.425p pd=3.18u as=0 ps=0 w=1.25u l=0.45u
X109 out.t1 a_9288_5041# vss.t28 vss.t29 sg13_hv_nmos ad=0.475p pd=2.88u as=0.475p ps=2.88u w=2.5u l=1u
X110 vdd a_592_286# w_8388_2366# vdd sg13_hv_pmos ad=1.425p pd=7.88u as=1.425p ps=7.88u w=7.5u l=4u
X111 vss.t57 a_8488_4945# a_9288_5041# vss.t56 sg13_hv_nmos ad=0.2375p pd=1.63u as=0.2375p ps=1.63u w=1.25u l=4u
X112 w_8388_2366# w_8388_2366# w_8388_2366# w_8388_2366# sg13_hv_pmos ad=1.425p pd=7.88u as=0 ps=0 w=7.5u l=0.4u
X113 vdd a_592_286# a_592_286# vdd sg13_hv_pmos ad=1.425p pd=7.88u as=1.425p ps=7.88u w=7.5u l=4u
X114 w_8388_2366# inp a_9288_5041# w_8388_2366# sg13_hv_pmos ad=0.7125p pd=4.13u as=0.7125p ps=4.13u w=3.75u l=2u
X115 vss.t28 a_9288_5041# out.t1 vss.t27 sg13_hv_nmos ad=0.475p pd=2.88u as=0.475p ps=2.88u w=2.5u l=1u
X116 vdd a_592_2733# a_592_2733# vdd sg13_hv_pmos ad=0.7125p pd=4.13u as=0.7125p ps=4.13u w=3.75u l=4u
X117 out a_1076_5541# vdd vdd sg13_hv_pmos ad=1.425p pd=7.88u as=1.425p ps=7.88u w=7.5u l=1u
X118 vdd a_3520_5051# w_8388_2366# vdd sg13_hv_pmos ad=0.7125p pd=4.13u as=0.7125p ps=4.13u w=3.75u l=4u
X119 a_9288_5041# a_1392_382# a_1076_5541# vss.t12 sg13_hv_nmos ad=0.475p pd=2.88u as=0.475p ps=2.88u w=2.5u l=1u
X120 a_1392_382# a_592_286# vdd vdd sg13_hv_pmos ad=1.425p pd=7.88u as=1.425p ps=7.88u w=7.5u l=4u
X121 w_8388_2366# w_8388_2366# w_8388_2366# w_8388_2366# sg13_hv_pmos ad=1.275p pd=8.18u as=0 ps=0 w=3.75u l=0.4u
X122 a_3520_5051# a_3520_5051# vdd vdd sg13_hv_pmos ad=0.7125p pd=4.13u as=0.7125p ps=4.13u w=3.75u l=4u
X123 a_12881_4979# a_14767_5343# vss.t37 rhigh l=9u w=1u
X124 a_9288_5041# a_5933_6071# vss.t16 vss.t19 sg13_hv_nmos ad=0.475p pd=2.88u as=0.475p ps=2.88u w=2.5u l=4u
X125 vdd a_1076_5541# out vdd sg13_hv_pmos ad=1.425p pd=7.88u as=1.425p ps=7.88u w=7.5u l=1u
X126 vss.t33 vss.t100 vss.t102 vss.t101 sg13_hv_nmos ad=0.475p pd=2.88u as=0 ps=0 w=2.5u l=0.45u
X127 a_12881_2795# a_14767_2795# vss.t68 rhigh l=9u w=1u
X128 w_8388_2366# a_592_286# a_4818_4945# w_8388_2366# sg13_hv_pmos ad=1.425p pd=7.88u as=1.425p ps=7.88u w=7.5u l=1u
X129 a_8488_4945# a_8488_4945# vss.t52 vss.t50 sg13_hv_nmos ad=0.2375p pd=1.63u as=0.2375p ps=1.63u w=1.25u l=4u
X130 vdd vdd vdd vdd sg13_hv_pmos ad=0.7125p pd=4.13u as=0 ps=0 w=3.75u l=0.4u
X131 vdd a_592_2733# a_592_2733# vdd sg13_hv_pmos ad=0.7125p pd=4.13u as=0.7125p ps=4.13u w=3.75u l=4u
X132 vss.t54 a_8488_4945# a_9288_5041# vss.t53 sg13_hv_nmos ad=0.2375p pd=1.63u as=0.2375p ps=1.63u w=1.25u l=4u
X133 a_12881_3523# a_14767_3159# vss.t69 rhigh l=9u w=1u
X134 vdd a_3520_5051# w_8388_2366# vdd sg13_hv_pmos ad=0.7125p pd=4.13u as=0.7125p ps=4.13u w=3.75u l=4u
X135 a_442_5111# a_442_5111# a_442_5111# vss.t4 sg13_hv_nmos ad=0.85p pd=5.68u as=0 ps=0 w=2.5u l=0.45u
X136 vdd vdd vdd vdd sg13_hv_pmos ad=2.55p pd=15.68u as=0 ps=0 w=7.5u l=0.4u
X137 a_592_286# a_592_286# vdd vdd sg13_hv_pmos ad=1.425p pd=7.88u as=1.425p ps=7.88u w=7.5u l=4u
X138 vss.t48 a_4818_4945# a_4818_4945# vss.t44 sg13_hv_nmos ad=0.2375p pd=1.63u as=0.2375p ps=1.63u w=1.25u l=4u
X139 a_442_5111# a_442_5111# a_442_5111# vss.t3 sg13_hv_nmos ad=0.2375p pd=1.63u as=0 ps=0 w=1.25u l=0.45u
X140 vdd vdd vdd vdd sg13_hv_pmos ad=1.425p pd=7.88u as=0 ps=0 w=7.5u l=0.4u
X141 a_592_286# ibias vss.t73 vss.t103 sg13_hv_nmos ad=0.475p pd=2.88u as=0.475p ps=2.88u w=2.5u l=4u
X142 vss.t33 a_9288_5041# out.t0 vss.t32 sg13_hv_nmos ad=0.475p pd=2.88u as=0.475p ps=2.88u w=2.5u l=1u
X143 out a_1076_5541# vdd vdd sg13_hv_pmos ad=1.425p pd=7.88u as=1.425p ps=7.88u w=7.5u l=1u
X144 a_1076_5541# a_1076_5541# a_1076_5541# vdd sg13_hv_pmos ad=2.55p pd=15.68u as=0 ps=0 w=7.5u l=1u
X145 vss.t60 a_8488_4945# a_8488_4945# vss.t56 sg13_hv_nmos ad=0.2375p pd=1.63u as=0.2375p ps=1.63u w=1.25u l=4u
X146 a_1076_5541# inp a_442_5111# vss.t63 sg13_hv_nmos ad=0.2375p pd=1.63u as=0.2375p ps=1.63u w=1.25u l=2u
X147 a_6733_6167# a_6733_6167# a_9508_346# vdd sg13_hv_pmos ad=1.425p pd=7.88u as=1.425p ps=7.88u w=7.5u l=1u
X148 w_8388_2366# inp a_9288_5041# w_8388_2366# sg13_hv_pmos ad=0.7125p pd=4.13u as=0.7125p ps=4.13u w=3.75u l=2u
X149 a_6733_6167# a_5933_6071# vss.t14 vss.t13 sg13_hv_nmos ad=0.475p pd=2.88u as=0.475p ps=2.88u w=2.5u l=4u
X150 vdd a_1076_5541# out vdd sg13_hv_pmos ad=1.425p pd=7.88u as=1.425p ps=7.88u w=7.5u l=1u
R0 out.t1 out.t0 3.11994
R1 out out.t1 1.21737
R2 vss.n406 vss.n405 55358.3
R3 vss.n10 vss.n79 0.0315271
R4 vss.n76 vss.t98 22.0289
R5 vss.n18 vss.n74 0.0396081
R6 vss.n16 vss.t88 96.1966
R7 vss.n15 vss.n184 93.268
R8 vss.t32 vss.n89 92.6702
R9 vss.t31 vss.n4 88.8232
R10 vss.t1 vss.n186 85.7681
R11 vss.n403 vss.n88 85.2665
R12 vss.n16 vss.t8 85.107
R13 vss.t30 vss.n5 82.9002
R14 vss.t0 vss.n14 82.4923
R15 vss.n283 vss.n132 80.4072
R16 vss.n282 vss.n101 80.4072
R17 vss.n281 vss.n131 80.4072
R18 vss.n280 vss.n102 80.4072
R19 vss.n276 vss.n130 80.4072
R20 vss.n275 vss.n103 80.4072
R21 vss.n274 vss.n129 80.4072
R22 vss.n273 vss.n104 80.4072
R23 vss.n272 vss.n128 80.4072
R24 vss.n271 vss.n105 80.4072
R25 vss.n270 vss.n127 80.4072
R26 vss.n267 vss.n107 80.4072
R27 vss.n266 vss.n125 80.4072
R28 vss.n265 vss.n108 80.4072
R29 vss.n264 vss.n124 80.4072
R30 vss.n263 vss.n109 80.4072
R31 vss.n262 vss.n123 80.4072
R32 vss.n261 vss.n110 80.4072
R33 vss.n259 vss.n111 80.4072
R34 vss.n258 vss.n121 80.4072
R35 vss.n255 vss.n113 80.4072
R36 vss.n254 vss.n119 80.4072
R37 vss.n252 vss.n118 80.4072
R38 vss.n251 vss.n115 80.4072
R39 vss.n250 vss.n117 80.4072
R40 vss.n165 vss.n55 78.7062
R41 vss.n166 vss.n56 78.7062
R42 vss.n169 vss.n59 78.7062
R43 vss.n170 vss.n60 78.7062
R44 vss.n171 vss.n61 78.7062
R45 vss.n172 vss.n62 78.7062
R46 vss.n173 vss.n63 78.7062
R47 vss.n174 vss.n64 78.7062
R48 vss.n176 vss.n66 78.7062
R49 vss.n177 vss.n67 78.7062
R50 vss.n178 vss.n68 78.7062
R51 vss.n179 vss.n69 78.7062
R52 vss.n181 vss.n71 78.7062
R53 vss.n182 vss.n72 78.7062
R54 vss.n183 vss.n73 78.7062
R55 vss.n9 vss.t22 76.9772
R56 vss.t29 vss.n6 76.9772
R57 vss.n8 vss.t24 71.0542
R58 vss.t27 vss.n7 71.0542
R59 vss.n75 vss.t106 28.8749
R60 vss.t26 vss.n8 65.1312
R61 vss.n7 vss.t26 65.1312
R62 vss.t79 vss.n122 63.7713
R63 vss.t83 vss.n75 63.1271
R64 vss.t4 vss.n15 60.4759
R65 vss.n284 vss.t19 59.6123
R66 vss.n6 vss.t27 59.2082
R67 vss.t24 vss.n9 59.2082
R68 vss.t108 vss.n185 58.2211
R69 vss.n168 vss.t61 57.718
R70 vss.n175 vss.t62 57.718
R71 vss.n14 vss.t4 57.5678
R72 vss.t104 vss.n57 56.4063
R73 vss.n186 vss.t108 55.5976
R74 vss.n5 vss.t29 53.2852
R75 vss.t22 vss.n76 53.2619
R76 vss.n18 vss.n22 22.3106
R77 vss.n148 vss.n39 52.471
R78 vss.n149 vss.n40 52.471
R79 vss.n150 vss.n41 52.471
R80 vss.n151 vss.n42 52.471
R81 vss.n152 vss.n43 52.471
R82 vss.n153 vss.n44 52.471
R83 vss.n155 vss.n46 52.471
R84 vss.n156 vss.n47 52.471
R85 vss.n157 vss.n48 52.471
R86 vss.n158 vss.n49 52.471
R87 vss.n159 vss.n50 52.471
R88 vss.n160 vss.n51 52.471
R89 vss.n162 vss.n53 52.471
R90 vss.n163 vss.n54 52.471
R91 vss.n249 vss.t11 51.2944
R92 vss.n75 vss.n18 0.0208618
R93 vss.t56 vss.n120 49.9081
R94 vss.n164 vss.n54 49.0388
R95 vss.n268 vss.t20 48.5218
R96 vss.n4 vss.t30 47.3622
R97 vss.n333 vss.n187 47.2239
R98 vss.n342 vss.n188 47.2239
R99 vss.n332 vss.n189 47.2239
R100 vss.n343 vss.n190 47.2239
R101 vss.n331 vss.n191 47.2239
R102 vss.n344 vss.n192 47.2239
R103 vss.n330 vss.n193 47.2239
R104 vss.n346 vss.n196 47.2239
R105 vss.n328 vss.n197 47.2239
R106 vss.n347 vss.n198 47.2239
R107 vss.n327 vss.n199 47.2239
R108 vss.n348 vss.n200 47.2239
R109 vss.n326 vss.n201 47.2239
R110 vss.n349 vss.n202 47.2239
R111 vss.n325 vss.n203 47.2239
R112 vss.n350 vss.n204 47.2239
R113 vss.n324 vss.n205 47.2239
R114 vss.n351 vss.n206 47.2239
R115 vss.n352 vss.n208 47.2239
R116 vss.n322 vss.n209 47.2239
R117 vss.n353 vss.n210 47.2239
R118 vss.n321 vss.n211 47.2239
R119 vss.n354 vss.n212 47.2239
R120 vss.n320 vss.n213 47.2239
R121 vss.n355 vss.n214 47.2239
R122 vss.n319 vss.n215 47.2239
R123 vss.n356 vss.n216 47.2239
R124 vss.n318 vss.n217 47.2239
R125 vss.n357 vss.n218 47.2239
R126 vss.n317 vss.n219 47.2239
R127 vss.n358 vss.n220 47.2239
R128 vss.n316 vss.n221 47.2239
R129 vss.n359 vss.n222 47.2239
R130 vss.n360 vss.n224 47.2239
R131 vss.n314 vss.n225 47.2239
R132 vss.n361 vss.n226 47.2239
R133 vss.n313 vss.n227 47.2239
R134 vss.n362 vss.n228 47.2239
R135 vss.n312 vss.n229 47.2239
R136 vss.n363 vss.n230 47.2239
R137 vss.n311 vss.n231 47.2239
R138 vss.n366 vss.n232 47.2239
R139 vss.n310 vss.n233 47.2239
R140 vss.n412 vss.n234 47.2239
R141 vss.n411 vss.n235 47.2239
R142 vss.n409 vss.n237 47.2239
R143 vss.n408 vss.n239 47.2239
R144 vss.n417 vss.n416 47.1354
R145 vss.n416 vss.n90 47.1354
R146 vss.n303 vss.n90 47.1354
R147 vss.n303 vss.n142 47.1354
R148 vss.n302 vss.n142 47.1354
R149 vss.n302 vss.n91 47.1354
R150 vss.n301 vss.n91 47.1354
R151 vss.n301 vss.n141 47.1354
R152 vss.n300 vss.n141 47.1354
R153 vss.n300 vss.n92 47.1354
R154 vss.n299 vss.n92 47.1354
R155 vss.n299 vss.n140 47.1354
R156 vss.n298 vss.n140 47.1354
R157 vss.n298 vss.n93 47.1354
R158 vss.n297 vss.n139 47.1354
R159 vss.n296 vss.n94 47.1354
R160 vss.n295 vss.n94 47.1354
R161 vss.n295 vss.n138 47.1354
R162 vss.n294 vss.n138 47.1354
R163 vss.n294 vss.n95 47.1354
R164 vss.n293 vss.n95 47.1354
R165 vss.n293 vss.n137 47.1354
R166 vss.n292 vss.n137 47.1354
R167 vss.n292 vss.n96 47.1354
R168 vss.n291 vss.n96 47.1354
R169 vss.n291 vss.n136 47.1354
R170 vss.n290 vss.n136 47.1354
R171 vss.n290 vss.n97 47.1354
R172 vss.n289 vss.n97 47.1354
R173 vss.n289 vss.n135 47.1354
R174 vss.n288 vss.n135 47.1354
R175 vss.n288 vss.n98 47.1354
R176 vss.n287 vss.n98 47.1354
R177 vss.n287 vss.n134 47.1354
R178 vss.n286 vss.n134 47.1354
R179 vss.n286 vss.n99 47.1354
R180 vss.n285 vss.n99 47.1354
R181 vss.n285 vss.n133 47.1354
R182 vss.t107 vss.n70 45.9122
R183 vss.t86 vss.n240 45.9122
R184 vss.n253 vss.t10 45.7491
R185 vss.n417 vss.t86 44.1834
R186 vss.t15 vss.n223 43.2887
R187 vss.n391 vss.n17 42.1311
R188 vss.n333 vss.n188 41.9769
R189 vss.n342 vss.n189 41.9769
R190 vss.n332 vss.n190 41.9769
R191 vss.n343 vss.n191 41.9769
R192 vss.n331 vss.n192 41.9769
R193 vss.n344 vss.n193 41.9769
R194 vss.n330 vss.n194 41.9769
R195 vss.n345 vss.n195 41.9769
R196 vss.n329 vss.n196 41.9769
R197 vss.n346 vss.n197 41.9769
R198 vss.n328 vss.n198 41.9769
R199 vss.n347 vss.n199 41.9769
R200 vss.n327 vss.n200 41.9769
R201 vss.n348 vss.n201 41.9769
R202 vss.n326 vss.n202 41.9769
R203 vss.n325 vss.n204 41.9769
R204 vss.n350 vss.n205 41.9769
R205 vss.n324 vss.n206 41.9769
R206 vss.n351 vss.n207 41.9769
R207 vss.n323 vss.n208 41.9769
R208 vss.n352 vss.n209 41.9769
R209 vss.n322 vss.n210 41.9769
R210 vss.n321 vss.n212 41.9769
R211 vss.n354 vss.n213 41.9769
R212 vss.n320 vss.n214 41.9769
R213 vss.n355 vss.n215 41.9769
R214 vss.n319 vss.n216 41.9769
R215 vss.n356 vss.n217 41.9769
R216 vss.n318 vss.n218 41.9769
R217 vss.n357 vss.n219 41.9769
R218 vss.n358 vss.n221 41.9769
R219 vss.n316 vss.n222 41.9769
R220 vss.n359 vss.n223 41.9769
R221 vss.n315 vss.n224 41.9769
R222 vss.n360 vss.n225 41.9769
R223 vss.n314 vss.n226 41.9769
R224 vss.n361 vss.n227 41.9769
R225 vss.n313 vss.n228 41.9769
R226 vss.n362 vss.n229 41.9769
R227 vss.n312 vss.n230 41.9769
R228 vss.n363 vss.n231 41.9769
R229 vss.n311 vss.n232 41.9769
R230 vss.n310 vss.n234 41.9769
R231 vss.n412 vss.n235 41.9769
R232 vss.n411 vss.n236 41.9769
R233 vss.n410 vss.n237 41.9769
R234 vss.n409 vss.n238 41.9769
R235 vss.n407 vss.n239 41.9769
R236 vss.n408 vss.n240 41.9769
R237 vss.n284 vss.t53 41.5901
R238 vss.n269 vss.t55 41.5901
R239 vss.n403 vss.n89 40.844
R240 vss.n187 vss.t83 40.6651
R241 vss.n257 vss.t6 40.2038
R242 vss.t6 vss.n112 40.2038
R243 vss.n88 vss.t31 39.3632
R244 vss.n323 vss.t41 39.3534
R245 vss.n317 vss.t43 39.3534
R246 vss.t68 vss.n400 39.0202
R247 vss.t49 vss.n397 39.0202
R248 vss.t55 vss.n106 38.8175
R249 vss.t8 vss.n17 37.9711
R250 vss.t65 vss.n394 37.348
R251 vss.n147 vss.n37 36.7298
R252 vss.n148 vss.n38 36.7298
R253 vss.n149 vss.n39 36.7298
R254 vss.n151 vss.n41 36.7298
R255 vss.n152 vss.n42 36.7298
R256 vss.n153 vss.n43 36.7298
R257 vss.n154 vss.n44 36.7298
R258 vss.n156 vss.n46 36.7298
R259 vss.n157 vss.n47 36.7298
R260 vss.n158 vss.n48 36.7298
R261 vss.n159 vss.n49 36.7298
R262 vss.n160 vss.n50 36.7298
R263 vss.n161 vss.n51 36.7298
R264 vss.n162 vss.n52 36.7298
R265 vss.n163 vss.n53 36.7298
R266 vss.n349 vss.t76 36.7298
R267 vss.n79 vss.t32 35.522
R268 vss.t13 vss.n211 35.4181
R269 vss.n393 vss.t34 34.8424
R270 vss.t10 vss.n114 34.6585
R271 vss.t72 vss.n38 34.1063
R272 vss.n35 vss.t12 11.873
R273 vss.n185 vss.t0 33.2976
R274 vss.n396 vss.t66 33.1702
R275 vss.n150 vss.t2 32.7946
R276 vss.n180 vss.t107 32.7946
R277 vss.t17 vss.n236 32.7946
R278 vss.t20 vss.n126 31.8859
R279 vss.n399 vss.t69 31.514
R280 vss.n402 vss.t67 31.4979
R281 vss.n154 vss.t63 31.4828
R282 vss.n161 vss.t64 31.4828
R283 vss.n407 vss.n406 31.4828
R284 vss.n297 vss.t50 30.4996
R285 vss.n256 vss.t56 30.4996
R286 vss.t11 vss.n116 29.1133
R287 vss.t70 vss.n399 28.9915
R288 vss.t36 vss.n396 28.9868
R289 vss.n345 vss.t38 28.8593
R290 vss.n366 vss.t44 28.8593
R291 vss.n405 vss.n404 28.1986
R292 vss.n76 vss.n10 0.060606
R293 vss.t37 vss.n393 27.3145
R294 vss.t103 vss.n45 24.924
R295 vss.t109 vss.n195 24.924
R296 vss.n394 vss.t37 24.809
R297 vss.t18 vss.n139 23.568
R298 vss.n296 vss.t18 23.568
R299 vss.n400 vss.t70 23.1367
R300 vss.n397 vss.t36 23.1367
R301 vss.n164 vss.n55 22.8035
R302 vss.n405 vss.n402 22.7159
R303 vss.n167 vss.t104 22.3005
R304 vss.n329 vss.t109 22.3005
R305 vss.t5 vss.n74 17.3475
R306 vss.t63 vss.n45 20.9887
R307 vss.t64 vss.n52 20.9887
R308 vss.t61 vss.n58 20.9887
R309 vss.t62 vss.n65 20.9887
R310 vss.t19 vss.n100 20.7953
R311 vss.t67 vss.n401 20.7093
R312 vss.t69 vss.n398 20.7093
R313 vss.t101 vss.n79 16.3867
R314 vss.t66 vss.n395 19.0371
R315 vss.n147 vss.t72 18.3652
R316 vss.t38 vss.n194 18.3652
R317 vss.n35 vss.n26 0.0135606
R318 vss.n18 vss.n419 17.0005
R319 vss.n87 vss.n18 17.0005
R320 vss.n145 vss.n18 17.0005
R321 vss.n18 vss.n86 17.0005
R322 vss.n18 vss.n25 8.49485
R323 vss.n24 vss.n25 0.0132937
R324 vss.n10 vss.n80 17.0005
R325 vss.n2 vss.n3 0.0248554
R326 vss.n10 vss.n3 5.65686
R327 vss.n1 vss.n10 0.950551
R328 vss.n418 vss.n12 17.0005
R329 vss.n12 vss.n146 17.0005
R330 vss.n12 vss.n144 17.0005
R331 vss.n12 vss.n143 17.0005
R332 vss.n12 vss.n23 8.49711
R333 vss.n12 vss.n2 8.49554
R334 vss.n3 vss.n0 0.0929957
R335 vss.n0 vss.n12 2.80981
R336 vss.n1 vss.n0 0.0826761
R337 vss.n309 vss.t45 17.0005
R338 vss.t85 vss.t52 17.0005
R339 vss.n413 vss.n278 17.0005
R340 vss.n414 vss.n413 17.0005
R341 vss.n415 vss.n278 17.0005
R342 vss.n415 vss.n414 17.0005
R343 vss.t48 vss.t93 17.0005
R344 vss.n306 vss.t51 17.0005
R345 vss.n415 vss.n244 17.0005
R346 vss.n415 vss.n248 17.0005
R347 vss.n247 vss.t57 17.0005
R348 vss.t87 vss.t89 17.0005
R349 vss.t60 vss.t95 17.0005
R350 vss.n243 vss.t96 17.0005
R351 vss.n18 vss.n417 17.0005
R352 vss.n18 vss.n90 17.0005
R353 vss.n18 vss.n142 17.0005
R354 vss.n18 vss.n91 17.0005
R355 vss.n18 vss.n141 17.0005
R356 vss.n18 vss.n92 17.0005
R357 vss.n18 vss.n140 17.0005
R358 vss.n18 vss.n93 17.0005
R359 vss.n18 vss.n139 17.0005
R360 vss.n18 vss.n94 17.0005
R361 vss.n18 vss.n138 17.0005
R362 vss.n18 vss.n95 17.0005
R363 vss.n18 vss.n137 17.0005
R364 vss.n18 vss.n96 17.0005
R365 vss.n18 vss.n136 17.0005
R366 vss.n18 vss.n97 17.0005
R367 vss.n18 vss.n135 17.0005
R368 vss.n18 vss.n98 17.0005
R369 vss.n18 vss.n134 17.0005
R370 vss.n18 vss.n99 17.0005
R371 vss.n18 vss.n133 17.0005
R372 vss.n18 vss.n100 17.0005
R373 vss.n18 vss.n132 17.0005
R374 vss.n18 vss.n101 17.0005
R375 vss.n18 vss.n131 17.0005
R376 vss.n18 vss.n102 17.0005
R377 vss.n18 vss.n130 17.0005
R378 vss.n18 vss.n103 17.0005
R379 vss.n18 vss.n129 17.0005
R380 vss.n18 vss.n104 17.0005
R381 vss.n18 vss.n128 17.0005
R382 vss.n18 vss.n105 17.0005
R383 vss.n18 vss.n127 17.0005
R384 vss.n18 vss.n106 17.0005
R385 vss.n18 vss.n126 17.0005
R386 vss.n18 vss.n107 17.0005
R387 vss.n18 vss.n125 17.0005
R388 vss.n18 vss.n108 17.0005
R389 vss.n18 vss.n124 17.0005
R390 vss.n18 vss.n109 17.0005
R391 vss.n18 vss.n123 17.0005
R392 vss.n18 vss.n110 17.0005
R393 vss.n18 vss.n122 17.0005
R394 vss.n18 vss.n111 17.0005
R395 vss.n18 vss.n121 17.0005
R396 vss.n18 vss.n112 17.0005
R397 vss.n18 vss.n120 17.0005
R398 vss.n18 vss.n113 17.0005
R399 vss.n18 vss.n119 17.0005
R400 vss.n18 vss.n114 17.0005
R401 vss.n18 vss.n118 17.0005
R402 vss.n18 vss.n115 17.0005
R403 vss.n18 vss.n117 17.0005
R404 vss.n18 vss.n116 17.0005
R405 vss.n18 vss.n147 17.0005
R406 vss.n18 vss.n148 17.0005
R407 vss.n18 vss.n149 17.0005
R408 vss.n18 vss.n150 17.0005
R409 vss.n18 vss.n151 17.0005
R410 vss.n18 vss.n152 17.0005
R411 vss.n18 vss.n153 17.0005
R412 vss.n18 vss.n154 17.0005
R413 vss.n18 vss.n155 17.0005
R414 vss.n18 vss.n156 17.0005
R415 vss.n18 vss.n157 17.0005
R416 vss.n18 vss.n158 17.0005
R417 vss.n18 vss.n159 17.0005
R418 vss.n18 vss.n160 17.0005
R419 vss.n18 vss.n161 17.0005
R420 vss.n18 vss.n162 17.0005
R421 vss.n18 vss.n163 17.0005
R422 vss.n18 vss.n165 17.0005
R423 vss.n18 vss.n166 17.0005
R424 vss.n18 vss.n167 17.0005
R425 vss.n18 vss.n168 17.0005
R426 vss.n18 vss.n169 17.0005
R427 vss.n18 vss.n170 17.0005
R428 vss.n18 vss.n171 17.0005
R429 vss.n18 vss.n172 17.0005
R430 vss.n18 vss.n173 17.0005
R431 vss.n18 vss.n174 17.0005
R432 vss.n18 vss.n175 17.0005
R433 vss.n18 vss.n176 17.0005
R434 vss.n18 vss.n177 17.0005
R435 vss.n18 vss.n178 17.0005
R436 vss.n18 vss.n179 17.0005
R437 vss.n18 vss.n180 17.0005
R438 vss.n18 vss.n181 17.0005
R439 vss.n18 vss.n182 17.0005
R440 vss.n18 vss.n183 17.0005
R441 vss.n18 vss.n187 17.0005
R442 vss.n18 vss.n188 17.0005
R443 vss.n18 vss.n189 17.0005
R444 vss.n18 vss.n190 17.0005
R445 vss.n18 vss.n191 17.0005
R446 vss.n18 vss.n192 17.0005
R447 vss.n18 vss.n193 17.0005
R448 vss.n18 vss.n194 17.0005
R449 vss.n18 vss.n195 17.0005
R450 vss.n18 vss.n196 17.0005
R451 vss.n18 vss.n197 17.0005
R452 vss.n18 vss.n198 17.0005
R453 vss.n18 vss.n199 17.0005
R454 vss.n18 vss.n200 17.0005
R455 vss.n18 vss.n201 17.0005
R456 vss.n18 vss.n202 17.0005
R457 vss.n18 vss.n203 17.0005
R458 vss.n18 vss.n204 17.0005
R459 vss.n18 vss.n205 17.0005
R460 vss.n18 vss.n206 17.0005
R461 vss.n18 vss.n207 17.0005
R462 vss.n18 vss.n208 17.0005
R463 vss.n18 vss.n209 17.0005
R464 vss.n18 vss.n210 17.0005
R465 vss.n18 vss.n211 17.0005
R466 vss.n18 vss.n212 17.0005
R467 vss.n18 vss.n213 17.0005
R468 vss.n18 vss.n214 17.0005
R469 vss.n18 vss.n215 17.0005
R470 vss.n18 vss.n216 17.0005
R471 vss.n18 vss.n217 17.0005
R472 vss.n18 vss.n218 17.0005
R473 vss.n18 vss.n219 17.0005
R474 vss.n18 vss.n220 17.0005
R475 vss.n18 vss.n221 17.0005
R476 vss.n18 vss.n222 17.0005
R477 vss.n18 vss.n223 17.0005
R478 vss.n18 vss.n224 17.0005
R479 vss.n18 vss.n225 17.0005
R480 vss.n18 vss.n226 17.0005
R481 vss.n18 vss.n227 17.0005
R482 vss.n18 vss.n228 17.0005
R483 vss.n18 vss.n229 17.0005
R484 vss.n18 vss.n230 17.0005
R485 vss.n18 vss.n231 17.0005
R486 vss.n18 vss.n232 17.0005
R487 vss.n18 vss.n233 17.0005
R488 vss.n18 vss.n234 17.0005
R489 vss.n18 vss.n235 17.0005
R490 vss.n18 vss.n236 17.0005
R491 vss.n18 vss.n237 17.0005
R492 vss.n18 vss.n238 17.0005
R493 vss.n18 vss.n239 17.0005
R494 vss.n18 vss.n240 17.0005
R495 vss.n33 vss.n13 0.00517577
R496 vss.n33 vss.n68 17.0005
R497 vss.n33 vss.n67 17.0005
R498 vss.n33 vss.n66 17.0005
R499 vss.n33 vss.n65 17.0005
R500 vss.n33 vss.n63 17.0005
R501 vss.n33 vss.n62 17.0005
R502 vss.n33 vss.n61 17.0005
R503 vss.n33 vss.n60 17.0005
R504 vss.n33 vss.n59 17.0005
R505 vss.n33 vss.n58 17.0005
R506 vss.n33 vss.n57 17.0005
R507 vss.n33 vss.n56 17.0005
R508 vss.n33 vss.n55 17.0005
R509 vss.n33 vss.n54 17.0005
R510 vss.n33 vss.n53 17.0005
R511 vss.n33 vss.n52 17.0005
R512 vss.n33 vss.n51 17.0005
R513 vss.n33 vss.n50 17.0005
R514 vss.n33 vss.n49 17.0005
R515 vss.n33 vss.n48 17.0005
R516 vss.n33 vss.n47 17.0005
R517 vss.n33 vss.n46 17.0005
R518 vss.n33 vss.n45 17.0005
R519 vss.n33 vss.n44 17.0005
R520 vss.n33 vss.n43 17.0005
R521 vss.n33 vss.n42 17.0005
R522 vss.n33 vss.n41 17.0005
R523 vss.n33 vss.n40 17.0005
R524 vss.n33 vss.n39 17.0005
R525 vss.n33 vss.n38 17.0005
R526 vss.n33 vss.n37 17.0005
R527 vss.n12 vss.n73 8.49854
R528 vss.n12 vss.n72 8.49829
R529 vss.n12 vss.n71 8.49804
R530 vss.n12 vss.n70 8.49779
R531 vss.n13 vss.n69 8.49966
R532 vss.n12 vss.n68 17.0005
R533 vss.n12 vss.n67 17.0005
R534 vss.n12 vss.n66 17.0005
R535 vss.n12 vss.n65 17.0005
R536 vss.n12 vss.n64 8.49838
R537 vss.n12 vss.n63 17.0005
R538 vss.n12 vss.n62 17.0005
R539 vss.n12 vss.n61 17.0005
R540 vss.n12 vss.n60 17.0005
R541 vss.n12 vss.n59 17.0005
R542 vss.n12 vss.n58 17.0005
R543 vss.n12 vss.n57 17.0005
R544 vss.n12 vss.n56 17.0005
R545 vss.n12 vss.n55 17.0005
R546 vss.n12 vss.n54 17.0005
R547 vss.n12 vss.n53 17.0005
R548 vss.n12 vss.n52 17.0005
R549 vss.n12 vss.n51 17.0005
R550 vss.n12 vss.n50 17.0005
R551 vss.n12 vss.n49 17.0005
R552 vss.n12 vss.n48 17.0005
R553 vss.n12 vss.n47 17.0005
R554 vss.n12 vss.n46 17.0005
R555 vss.n12 vss.n45 17.0005
R556 vss.n12 vss.n44 17.0005
R557 vss.n12 vss.n43 17.0005
R558 vss.n12 vss.n42 17.0005
R559 vss.n12 vss.n41 17.0005
R560 vss.n12 vss.n40 17.0005
R561 vss.n12 vss.n39 17.0005
R562 vss.n12 vss.n38 17.0005
R563 vss.n22 vss.n37 10.1978
R564 vss.n413 vss.n341 17.0005
R565 vss.n413 vss.n337 17.0005
R566 vss.n336 vss.t84 17.0005
R567 vss.t82 vss.t40 17.0005
R568 vss.t92 vss.t90 17.0005
R569 vss.n340 vss.t39 17.0005
R570 vss.t21 vss.n82 4.24098
R571 vss.t21 vss.t78 17.0005
R572 vss.t81 vss.n77 4.23949
R573 vss.t80 vss.t81 17.0005
R574 vss.t97 vss.t23 17.0005
R575 vss.t102 vss.t100 17.0005
R576 vss.t77 vss.t75 17.0005
R577 vss.n370 vss.t14 17.0005
R578 vss.t74 vss.t71 17.0005
R579 vss.n423 vss.t73 17.0005
R580 vss.t50 vss.n93 16.6364
R581 vss.n260 vss.t79 16.6364
R582 vss.t34 vss.n392 16.074
R583 vss.n406 vss.n238 15.7416
R584 vss.n395 vss.t65 14.8603
R585 vss.n392 vss.n391 14.8207
R586 vss.n410 vss.t17 14.4299
R587 vss.n283 vss.n100 13.8637
R588 vss.n282 vss.n132 13.8637
R589 vss.n281 vss.n101 13.8637
R590 vss.n280 vss.n131 13.8637
R591 vss.n276 vss.n102 13.8637
R592 vss.n275 vss.n130 13.8637
R593 vss.n274 vss.n103 13.8637
R594 vss.n273 vss.n129 13.8637
R595 vss.n272 vss.n104 13.8637
R596 vss.n271 vss.n128 13.8637
R597 vss.n270 vss.n105 13.8637
R598 vss.n269 vss.n127 13.8637
R599 vss.n268 vss.n106 13.8637
R600 vss.n267 vss.n126 13.8637
R601 vss.n266 vss.n107 13.8637
R602 vss.n265 vss.n125 13.8637
R603 vss.n264 vss.n108 13.8637
R604 vss.n263 vss.n124 13.8637
R605 vss.n262 vss.n109 13.8637
R606 vss.n261 vss.n123 13.8637
R607 vss.n260 vss.n110 13.8637
R608 vss.n259 vss.n122 13.8637
R609 vss.n258 vss.n111 13.8637
R610 vss.n257 vss.n121 13.8637
R611 vss.n256 vss.n112 13.8637
R612 vss.n255 vss.n120 13.8637
R613 vss.n254 vss.n113 13.8637
R614 vss.n253 vss.n119 13.8637
R615 vss.n252 vss.n114 13.8637
R616 vss.n251 vss.n118 13.8637
R617 vss.n250 vss.n115 13.8637
R618 vss.n249 vss.n117 13.8637
R619 vss.n401 vss.t68 13.188
R620 vss.n398 vss.t49 13.188
R621 vss.t44 vss.n233 13.1181
R622 vss.t88 vss.n116 12.4774
R623 vss.n155 vss.t103 11.8064
R624 vss.n404 vss.n403 11.4754
R625 vss.n165 vss.n56 10.4946
R626 vss.n166 vss.n57 10.4946
R627 vss.n167 vss.n58 10.4946
R628 vss.n168 vss.n59 10.4946
R629 vss.n169 vss.n60 10.4946
R630 vss.n170 vss.n61 10.4946
R631 vss.n171 vss.n62 10.4946
R632 vss.n172 vss.n63 10.4946
R633 vss.n173 vss.n64 10.4946
R634 vss.n174 vss.n65 10.4946
R635 vss.n175 vss.n66 10.4946
R636 vss.n176 vss.n67 10.4946
R637 vss.n177 vss.n68 10.4946
R638 vss.n178 vss.n69 10.4946
R639 vss.n180 vss.n71 10.4946
R640 vss.n181 vss.n72 10.4946
R641 vss.n182 vss.n73 10.4946
R642 vss.n184 vss.n183 10.4946
R643 vss.n22 vss.n12 3.79676
R644 vss.n390 vss.n18 0.585295
R645 vss.n21 vss.n31 0.010294
R646 vss.n390 vss.n30 0.377681
R647 vss.t28 vss.n11 1.35834
R648 vss.n413 vss.n412 8.5005
R649 vss.n413 vss.n310 8.5005
R650 vss.n413 vss.n366 8.5005
R651 vss.n413 vss.n311 8.5005
R652 vss.n413 vss.n363 8.5005
R653 vss.n413 vss.n312 8.5005
R654 vss.n413 vss.n362 8.5005
R655 vss.n413 vss.n313 8.5005
R656 vss.n413 vss.n361 8.5005
R657 vss.n413 vss.n407 8.5005
R658 vss.n413 vss.n409 8.5005
R659 vss.n413 vss.n410 8.5005
R660 vss.n413 vss.n411 8.5005
R661 vss.n413 vss.n408 8.5005
R662 vss.n416 vss.n415 8.5005
R663 vss.n415 vss.n249 8.5005
R664 vss.n415 vss.n250 8.5005
R665 vss.n415 vss.n251 8.5005
R666 vss.n415 vss.n252 8.5005
R667 vss.n415 vss.n253 8.5005
R668 vss.n415 vss.n254 8.5005
R669 vss.n415 vss.n255 8.5005
R670 vss.n415 vss.n256 8.5005
R671 vss.n415 vss.n257 8.5005
R672 vss.n415 vss.n258 8.5005
R673 vss.n415 vss.n259 8.5005
R674 vss.n415 vss.n260 8.5005
R675 vss.n415 vss.n261 8.5005
R676 vss.n415 vss.n262 8.5005
R677 vss.n415 vss.n263 8.5005
R678 vss.n415 vss.n264 8.5005
R679 vss.n415 vss.n265 8.5005
R680 vss.n415 vss.n266 8.5005
R681 vss.n415 vss.n267 8.5005
R682 vss.n415 vss.n268 8.5005
R683 vss.n415 vss.n269 8.5005
R684 vss.n415 vss.n270 8.5005
R685 vss.n415 vss.n271 8.5005
R686 vss.n415 vss.n272 8.5005
R687 vss.n415 vss.n273 8.5005
R688 vss.n415 vss.n274 8.5005
R689 vss.n415 vss.n275 8.5005
R690 vss.n415 vss.n276 8.5005
R691 vss.n415 vss.n280 8.5005
R692 vss.n415 vss.n281 8.5005
R693 vss.n415 vss.n282 8.5005
R694 vss.n415 vss.n283 8.5005
R695 vss.n415 vss.n284 8.5005
R696 vss.n415 vss.n285 8.5005
R697 vss.n415 vss.n286 8.5005
R698 vss.n415 vss.n287 8.5005
R699 vss.n415 vss.n288 8.5005
R700 vss.n415 vss.n289 8.5005
R701 vss.n415 vss.n290 8.5005
R702 vss.n415 vss.n291 8.5005
R703 vss.n415 vss.n292 8.5005
R704 vss.n415 vss.n293 8.5005
R705 vss.n415 vss.n294 8.5005
R706 vss.n415 vss.n295 8.5005
R707 vss.n415 vss.n296 8.5005
R708 vss.n415 vss.n297 8.5005
R709 vss.n415 vss.n298 8.5005
R710 vss.n415 vss.n299 8.5005
R711 vss.n415 vss.n300 8.5005
R712 vss.n415 vss.n301 8.5005
R713 vss.n415 vss.n302 8.5005
R714 vss.n415 vss.n303 8.5005
R715 vss.n413 vss.n314 8.5005
R716 vss.n413 vss.n360 8.5005
R717 vss.n413 vss.n315 8.5005
R718 vss.n413 vss.n359 8.5005
R719 vss.n413 vss.n316 8.5005
R720 vss.n413 vss.n358 8.5005
R721 vss.n413 vss.n317 8.5005
R722 vss.n413 vss.n357 8.5005
R723 vss.n413 vss.n318 8.5005
R724 vss.n413 vss.n356 8.5005
R725 vss.n413 vss.n319 8.5005
R726 vss.n413 vss.n355 8.5005
R727 vss.n413 vss.n320 8.5005
R728 vss.n413 vss.n354 8.5005
R729 vss.n413 vss.n321 8.5005
R730 vss.n413 vss.n353 8.5005
R731 vss.n413 vss.n322 8.5005
R732 vss.n413 vss.n352 8.5005
R733 vss.n413 vss.n323 8.5005
R734 vss.n413 vss.n351 8.5005
R735 vss.n413 vss.n324 8.5005
R736 vss.n413 vss.n350 8.5005
R737 vss.n413 vss.n325 8.5005
R738 vss.n413 vss.n349 8.5005
R739 vss.n413 vss.n326 8.5005
R740 vss.n413 vss.n348 8.5005
R741 vss.n413 vss.n327 8.5005
R742 vss.n413 vss.n347 8.5005
R743 vss.n413 vss.n328 8.5005
R744 vss.n413 vss.n346 8.5005
R745 vss.n413 vss.n329 8.5005
R746 vss.n413 vss.n345 8.5005
R747 vss.n413 vss.n330 8.5005
R748 vss.n413 vss.n344 8.5005
R749 vss.n413 vss.n331 8.5005
R750 vss.n413 vss.n343 8.5005
R751 vss.n413 vss.n332 8.5005
R752 vss.n413 vss.n342 8.5005
R753 vss.n413 vss.n333 8.5005
R754 vss.t21 vss.n386 8.49188
R755 vss.n385 vss.t7 8.49188
R756 vss.t99 vss.n374 8.49188
R757 vss.n373 vss.t23 8.49188
R758 vss.n379 vss.t33 8.49188
R759 vss.t102 vss.n378 8.49188
R760 vss.n387 vss.t7 8.49176
R761 vss.t99 vss.n372 8.49176
R762 vss.t33 vss.n377 8.49176
R763 vss.t9 vss.n382 8.49087
R764 vss.n383 vss.t81 8.49087
R765 vss.n369 vss.t77 8.49087
R766 vss.n368 vss.t14 8.49087
R767 vss.n422 vss.t74 8.49087
R768 vss.n421 vss.t73 8.49087
R769 vss.t9 vss.n384 8.49074
R770 vss.t45 vss.n308 8.48783
R771 vss.t52 vss.n307 8.48783
R772 vss.n305 vss.t48 8.48783
R773 vss.n304 vss.t51 8.48783
R774 vss.t57 vss.n246 8.48783
R775 vss.t89 vss.n245 8.48783
R776 vss.n242 vss.t60 8.48783
R777 vss.n241 vss.t96 8.48783
R778 vss.t84 vss.n335 8.48783
R779 vss.t40 vss.n334 8.48783
R780 vss.n339 vss.t92 8.48783
R781 vss.n338 vss.t39 8.48783
R782 vss.n32 vss.n29 2.11965
R783 vss.n29 vss.n28 0.873951
R784 vss.n36 vss.n12 0.0593157
R785 vss.n34 vss.n36 2.85433
R786 vss.t41 vss.n207 7.87107
R787 vss.n179 vss.t3 6.55931
R788 vss.n353 vss.t13 6.55931
R789 vss.n375 vss.t99 5.68329
R790 vss.n380 vss.t33 5.68329
R791 vss.n82 vss.t7 5.6831
R792 vss.t9 vss.n77 5.68522
R793 vss.n390 vss.n21 0.529267
R794 vss.n30 vss.n26 0.0112219
R795 vss.n184 vss.n12 1.06156
R796 vss.n18 vss.n19 0.376631
R797 vss.n32 vss.n31 0.189912
R798 vss.n27 vss.n26 0.00291929
R799 vss.t53 vss.n133 5.54579
R800 vss.t76 vss.n203 5.24755
R801 vss.t35 vss.n78 4.4755
R802 vss.t25 vss.n376 4.4755
R803 vss.t28 vss.n381 4.4755
R804 vss.n84 vss.n371 4.4755
R805 vss.t105 vss.n424 4.4755
R806 vss.t14 vss.n367 4.25206
R807 vss.t73 vss.n420 4.25206
R808 vss.t77 vss.n367 4.25175
R809 vss.t74 vss.n420 4.25175
R810 vss.n375 vss.t23 4.24047
R811 vss.n380 vss.t102 4.24047
R812 vss.n388 vss.n83 4.1005
R813 vss.t2 vss.n40 3.93579
R814 vss.t3 vss.n70 3.93579
R815 vss.n315 vss.t15 3.93579
R816 vss.t43 vss.n220 2.62402
R817 vss.n18 vss.n164 2.34678
R818 vss.n18 vss.n185 2.34678
R819 vss.n18 vss.n186 2.34678
R820 vss.n85 vss.n24 2.27125
R821 vss.n365 vss.t16 2.26086
R822 vss.n10 vss.n89 2.14665
R823 vss.n10 vss.n88 2.14665
R824 vss.n404 vss.n26 1.36272
R825 vss.n392 vss.n26 1.36272
R826 vss.n36 vss.n81 1.31543
R827 vss.n10 vss.n11 0.46615
R828 vss.n413 vss.n389 0.986957
R829 vss.n279 vss.t54 0.725985
R830 vss.t54 vss.n277 0.718957
R831 vss.t42 vss.n364 0.715539
R832 vss.n365 vss.t42 0.676742
R833 vss.n27 vss.n29 2.29351
R834 vss.n18 vss.n14 0.331038
R835 vss.n20 vss.n18 0.0161302
R836 vss.n32 vss.n20 2.74979
R837 vss.n27 vss.n11 1.98443
R838 vss.t35 vss.t25 0.309901
R839 vss.n18 vss.n16 0.305009
R840 vss.n18 vss.n17 0.305009
R841 vss.n389 vss.n365 0.253688
R842 vss.n389 vss.n279 0.243936
R843 vss.n84 vss.t105 0.231286
R844 vss.t16 vss.n388 0.135543
R845 vss.n402 vss.n26 0.120581
R846 vss.n400 vss.n26 0.120581
R847 vss.n397 vss.n26 0.120581
R848 vss.n396 vss.n26 0.120581
R849 vss.n394 vss.n26 0.120581
R850 vss.n393 vss.n26 0.120581
R851 vss.n399 vss.n26 0.116916
R852 vss.n34 vss.n33 0.0585243
R853 vss.n278 vss.n306 0.0899444
R854 vss.n414 vss.n309 0.0899444
R855 vss.n244 vss.n243 0.0899444
R856 vss.n248 vss.n247 0.0899444
R857 vss.n341 vss.n340 0.0899444
R858 vss.n337 vss.n336 0.0899444
R859 vss.t25 vss.t28 0.0835571
R860 vss.t16 vss.n84 0.0654286
R861 vss.n78 vss.n77 0.0491388
R862 vss.n83 vss.n82 0.0444465
R863 vss.n305 vss.n304 0.054196
R864 vss.n308 vss.n307 0.054196
R865 vss.n242 vss.n241 0.054196
R866 vss.n246 vss.n245 0.054196
R867 vss.n339 vss.n338 0.054196
R868 vss.n335 vss.n334 0.054196
R869 vss.n388 vss.t35 0.0533429
R870 vss.n18 vss.n15 0.0475125
R871 vss.n74 vss.t1 30.3123
R872 vss.n376 vss.n375 0.0448653
R873 vss.n381 vss.n380 0.0448653
R874 vss.n384 vss.n383 0.0422843
R875 vss.n19 vss.n81 0.999783
R876 vss.n383 vss.n382 0.0420072
R877 vss.n369 vss.n368 0.0420072
R878 vss.n422 vss.n421 0.0420072
R879 vss.n371 vss.n370 0.0410556
R880 vss.n424 vss.n423 0.0410556
R881 vss.n413 vss.t42 0.0383438
R882 vss.n371 vss.n367 0.0382434
R883 vss.n424 vss.n420 0.0382434
R884 vss.n387 vss.n386 0.0382103
R885 vss.n373 vss.n372 0.0382103
R886 vss.n378 vss.n377 0.0382103
R887 vss.n386 vss.n385 0.0379609
R888 vss.n374 vss.n373 0.0379609
R889 vss.n379 vss.n378 0.0379609
R890 vss.n401 vss.n26 0.0365679
R891 vss.n398 vss.n26 0.0365679
R892 vss.n395 vss.n26 0.0365679
R893 vss.n391 vss.n35 36.2015
R894 vss.n10 vss.n4 0.0363214
R895 vss.n10 vss.n5 0.0363214
R896 vss.n10 vss.n6 0.0363214
R897 vss.n10 vss.n7 0.0363214
R898 vss.n10 vss.n8 0.0363214
R899 vss.n10 vss.n9 0.0363214
R900 vss.n308 vss.t85 0.027348
R901 vss.n306 vss.n305 0.027348
R902 vss.t93 vss.n304 0.027348
R903 vss.n309 vss.n307 0.027348
R904 vss.n246 vss.t87 0.027348
R905 vss.n247 vss.n245 0.027348
R906 vss.n243 vss.n242 0.027348
R907 vss.t95 vss.n241 0.027348
R908 vss.n335 vss.t82 0.027348
R909 vss.n340 vss.n339 0.027348
R910 vss.t90 vss.n338 0.027348
R911 vss.n336 vss.n334 0.027348
R912 vss.n384 vss.t80 0.0215307
R913 vss.n370 vss.n369 0.0212536
R914 vss.t75 vss.n368 0.0212536
R915 vss.n423 vss.n422 0.0212536
R916 vss.t71 vss.n421 0.0212536
R917 vss.n385 vss.n83 0.0197304
R918 vss.n415 vss.t54 0.0195241
R919 vss.t78 vss.n387 0.0194799
R920 vss.n376 vss.n372 0.0194799
R921 vss.n381 vss.n377 0.0194799
R922 vss.n279 vss.n278 0.0193889
R923 vss.n414 vss.n279 0.0193889
R924 vss.n277 vss.n244 0.0193889
R925 vss.n277 vss.n248 0.0193889
R926 vss.n364 vss.n341 0.0193889
R927 vss.n364 vss.n337 0.0193889
R928 vss.n374 vss.t97 0.0192304
R929 vss.t100 vss.n379 0.0192304
R930 vss.n2 vss.n80 0.0274721
R931 vss.n24 vss.n23 0.00877605
R932 vss.n143 vss.n86 0.0160592
R933 vss.n145 vss.n144 0.0160592
R934 vss.n146 vss.n87 0.0160592
R935 vss.n419 vss.n418 0.0160592
R936 vss.n382 vss.n78 0.0218092
R937 vss.n28 vss.n31 0.0214887
R938 vss.n28 vss.n30 0.0114401
R939 vss.n80 vss.n23 0.0178221
R940 vss.n143 vss.n25 0.0223398
R941 vss.n144 vss.n86 0.00954605
R942 vss.n146 vss.n145 0.00954605
R943 vss.n418 vss.n87 0.00954605
R944 vss.n419 vss.n81 0.00954605
R945 vss.t105 vss.n85 0.00954286
R946 vss.n20 vss.n21 0.0173799
R947 vss.n85 vss.n19 4.7637
R948 vss.n10 vss.n26 0.032996
R949 vss.n18 vss.n10 0.0218653
R950 vss.n13 vss.n12 0.00517577
R951 vss.n34 vss.n1 1.32784
R952 vss vss.n0 0.0005
C0 a_6733_6167# inp 0.04296f
C1 a_9288_5041# a_5933_6071# 0.61977f
C2 a_592_2733# vdd 19.8957f
C3 inp vdd 0.12326f
C4 a_592_2733# a_592_286# 0.62365f
C5 a_6733_6167# a_1076_5541# 1.62117f
C6 a_6733_6167# a_4818_4945# 0.30974f
C7 a_9288_5041# a_14767_5343# 0.04052f
C8 a_9508_346# w_8388_2366# 0.01462f
C9 inp a_592_286# 0.43322f
C10 a_1076_5541# vdd 16.4562f
C11 vdd a_4818_4945# 0.15626f
C12 ibias a_592_286# 0.80911f
C13 inp a_8488_4945# 0.6188f
C14 a_1076_5541# a_12967_2795# 0.02684f
C15 a_12967_4979# a_14767_4615# 0.03876f
C16 a_1076_5541# a_12881_3523# 0.02244f
C17 a_14767_3159# a_14767_2795# 0.1032f
C18 a_11355_6131# a_1392_382# 0.61898f
C19 a_1076_5541# a_14767_4615# 0.02542f
C20 a_1076_5541# a_592_286# 1.93392f
C21 a_6733_6167# a_442_5111# 0.01655f
C22 a_4818_4945# a_592_286# 0.57749f
C23 a_6733_6167# inn 0.0433f
C24 a_4818_4945# a_8488_4945# 0.28196f
C25 a_12881_4979# a_12881_4251# 0.01672f
C26 a_12881_4251# a_12967_4615# 0.03876f
C27 w_8388_2366# a_12881_4251# 0.04f
C28 a_1076_5541# a_12967_3523# 0.02011f
C29 out vdd 2.11845f
C30 vdd a_442_5111# 0.03377f
C31 inn vdd 0.30448f
C32 a_12967_3159# a_12967_2795# 0.20927f
C33 a_12881_4979# a_12967_5343# 0.03876f
C34 a_9508_346# inp 0.01072f
C35 a_592_286# a_442_5111# 0.77885f
C36 a_6733_6167# a_9288_5041# 0.62999f
C37 inn a_592_286# 0.18492f
C38 a_12967_5707# a_9288_5041# 0.02198f
C39 w_8388_2366# a_1392_382# 1.34032f
C40 inn a_8488_4945# 1.31946f
C41 a_12967_3159# a_12967_3523# 0.20927f
C42 a_9508_346# a_1076_5541# 0.0855f
C43 a_9288_5041# vdd 0.66411f
C44 a_12967_3887# a_12881_3523# 0.03876f
C45 a_9288_5041# a_12967_2795# 0.04495f
C46 a_9288_5041# a_12881_3523# 0.02692f
C47 a_12967_2795# a_12967_2431# 0.20927f
C48 a_12967_3887# a_12967_3523# 0.20927f
C49 a_9288_5041# a_8488_4945# 1.38579f
C50 a_12881_2795# a_12967_2795# 0.03876f
C51 a_6733_6167# a_5933_6071# 2.25971f
C52 a_9288_5041# a_12967_3523# 0.05266f
C53 a_12881_2795# a_12881_3523# 0.01672f
C54 a_592_2733# a_1392_382# 0.08807f
C55 a_1076_5541# a_12881_4251# 0.04323f
C56 a_6733_6167# a_3520_5051# 0.12248f
C57 a_1076_5541# a_14767_2795# 0.08049f
C58 vdd a_5933_6071# 0.79989f
C59 inp a_1392_382# 0.20624f
C60 a_12967_5343# a_12967_4979# 0.20927f
C61 a_1076_5541# a_12967_5343# 0.04008f
C62 a_12967_5707# a_14767_5343# 0.04289f
C63 a_3520_5051# vdd 20.341f
C64 inp w_8388_2366# 6.12256f
C65 a_5933_6071# a_592_286# 1.18671f
C66 a_1076_5541# a_1392_382# 1.88462f
C67 a_5933_6071# a_8488_4945# 1.42862f
C68 a_12881_4979# a_12967_4979# 0.03876f
C69 a_12967_4615# a_12967_4979# 0.20927f
C70 a_3520_5051# a_592_286# 0.37968f
C71 out a_14767_2795# 0.33643p
C72 a_12881_4251# a_12967_4251# 0.03876f
C73 a_12967_3159# a_14767_2795# 0.04329f
C74 a_1076_5541# a_12881_4979# 0.02632f
C75 a_1076_5541# a_12967_4615# 0.06311f
C76 a_1076_5541# w_8388_2366# 0.18098f
C77 w_8388_2366# a_4818_4945# 0.54521f
C78 a_14767_5343# a_14767_4615# 0.10346f
C79 a_14767_3159# a_12967_3159# 0.03876f
C80 inp a_592_2733# 0.31895f
C81 a_11355_6131# a_9288_5041# 0.08475f
C82 inn a_1392_382# 0.1848f
C83 ibias a_592_2733# 0.04618f
C84 a_9288_5041# a_14767_2795# 1.0758f
C85 w_8388_2366# a_442_5111# 0.01993f
C86 a_12967_4615# a_12967_4251# 0.20927f
C87 inn w_8388_2366# 6.13335f
C88 ibias inp 0.16028f
C89 a_14767_2795# a_12967_2431# 0.0255f
C90 a_1076_5541# a_592_2733# 3.45441f
C91 a_9288_5041# a_14767_3159# 0.02632f
C92 a_6733_6167# vdd 3.98013f
C93 a_1076_5541# inp 0.6563f
C94 a_9288_5041# a_1392_382# 1.22566f
C95 inp a_4818_4945# 0.23197f
C96 ibias a_4818_4945# 0.44789f
C97 a_1076_5541# a_12967_4979# 0.04703f
C98 a_9288_5041# w_8388_2366# 1.17037f
C99 a_6733_6167# a_592_286# 0.08698f
C100 a_592_2733# a_442_5111# 0.34884f
C101 inn a_592_2733# 1.36419f
C102 vdd a_592_286# 39.8003f
C103 inp a_442_5111# 0.95508f
C104 inn inp 5.07118f
C105 a_12881_2795# w_8388_2366# 0.03879f
C106 ibias a_442_5111# 0.83126f
C107 inn ibias 0.12725f
C108 a_5933_6071# a_1392_382# 0.07674f
C109 a_1076_5541# out 2.50637f
C110 a_1076_5541# a_442_5111# 0.26405f
C111 a_8488_4945# a_592_286# 0.09532f
C112 a_4818_4945# a_442_5111# 1.04724f
C113 a_1076_5541# a_12967_3159# 0.02269f
C114 a_12967_3523# a_12881_3523# 0.03876f
C115 a_12967_5343# a_14767_5343# 0.08145f
C116 a_3520_5051# a_1392_382# 0.18479f
C117 a_1076_5541# inn 0.39797f
C118 a_1076_5541# a_12967_4251# 0.19604f
C119 w_8388_2366# a_5933_6071# 0.43298f
C120 inn a_4818_4945# 0.02908f
C121 a_9508_346# a_6733_6167# 1.06577f
C122 inp a_9288_5041# 1.40218f
C123 a_3520_5051# w_8388_2366# 1.95611f
C124 a_1076_5541# a_12967_3887# 0.03091f
C125 a_9508_346# vdd 2.73634f
C126 a_14767_5343# a_12967_4615# 0.04329f
C127 a_1076_5541# a_9288_5041# 3.56717f
C128 inn a_442_5111# 0.97231f
C129 a_1076_5541# a_12967_2431# 0.09942f
C130 a_9508_346# a_592_286# 0.04283f
C131 a_1076_5541# a_12881_2795# 0.02347f
C132 a_3520_5051# a_592_2733# 0.11013f
C133 inp a_5933_6071# 0.07536f
C134 a_12967_3887# a_12967_4251# 0.20927f
C135 out a_9288_5041# 1.36469f
C136 a_9288_5041# a_12967_3159# 0.04099f
C137 a_12967_5707# a_12967_5343# 0.20927f
C138 vdd a_14767_2795# 0.31715f
C139 a_3520_5051# inp 0.11543f
C140 inn a_9288_5041# 0.32254f
C141 a_9288_5041# a_12967_4251# 0.01473f
C142 a_12881_4251# a_12881_3523# 0.01672f
C143 a_12967_2795# a_14767_2795# 0.08145f
C144 a_3520_5051# ibias 0.01869f
C145 a_1076_5541# a_5933_6071# 0.13572f
C146 a_6733_6167# a_1392_382# 0.636f
C147 a_5933_6071# a_4818_4945# 1.14036f
C148 a_12967_5707# a_1392_382# 0.05833f
C149 a_11355_6131# a_8488_4945# 0.05561f
C150 a_12881_2795# a_12967_3159# 0.03876f
C151 a_1076_5541# a_3520_5051# 0.20675f
C152 a_9288_5041# a_12967_3887# 0.17703f
C153 a_3520_5051# a_4818_4945# 0.78505f
C154 a_6733_6167# w_8388_2366# 0.34064f
C155 vdd a_1392_382# 2.12514f
C156 a_14767_5343# a_12967_4979# 0.04329f
C157 a_14767_2795# a_12967_3523# 0.04329f
C158 a_1076_5541# a_14767_5343# 0.08664f
C159 w_8388_2366# vdd 1.65987f
C160 a_9288_5041# a_12967_2431# 0.01328f
C161 a_5933_6071# a_442_5111# 0.06572f
C162 a_1392_382# a_592_286# 1.91613f
C163 a_14767_3159# a_12967_3523# 0.03876f
C164 inn a_5933_6071# 0.02645f
C165 a_1392_382# a_8488_4945# 0.3486f
C166 w_8388_2366# a_12881_3523# 0.04192f
C167 a_12967_4615# a_14767_4615# 0.03876f
C168 a_3520_5051# a_442_5111# 0.44282f
C169 w_8388_2366# a_592_286# 3.48603f
C170 a_3520_5051# inn 0.41738f
C171 w_8388_2366# a_8488_4945# 1.83939f
C172 out a_14767_5343# 0.33471p
C173 a_14767_5343# a_12967_4251# 0.01305f
C174 out vss 71.09376f
C175 a_14767_2795# vss 14.04592f
C176 a_12881_2795# vss 1.69786f
C177 a_14767_3159# vss 1.63674f
C178 a_12881_3523# vss 1.6197f
C179 a_12881_4251# vss 1.62754f
C180 a_14767_4615# vss 1.64562f
C181 a_14767_5343# vss 14.93403f
C182 a_12881_4979# vss 1.7587f
C183 vss.t54 vss 1.02725f
C184 vss.t51 vss 5.7551f
C185 vss.t42 vss 6.238f
C186 vss.t77 vss 6.62485f
C187 vss.t25 vss 6.59782f
C188 vss.t35 vss 2.10688f
C189 vss.t23 vss 0.32334f
C190 vss.t28 vss 6.29915f
C191 vss.t7 vss 2.61405f
C192 vss.t16 vss 6.25885f
C193 out.t0 vss 83.29445f

C200 a_9288_5041# out 360f
C201 a_1076_5541# out 360f

.ends
