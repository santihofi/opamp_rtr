* NGSPICE file created from opamp_rtr_pex.ext - technology: ihp-sg13cmos5l

.subckt opamp_rtr_pex vdd inp vss inn ibias out
X0 out.t1 a_9288_5041# vss.t25 vss.t30 sg13_hv_nmos ad=0.475p pd=2.88u as=0.475p ps=2.88u w=2.5u l=1u
X1 vdd a_592_286# a_1392_382# vdd sg13_hv_pmos ad=1.425p pd=7.88u as=1.425p ps=7.88u w=7.5u l=4u
X2 w_8388_2366# w_8388_2366# w_8388_2366# w_8388_2366# sg13_hv_pmos ad=0.7125p pd=4.13u as=62.7835p ps=0.25869m w=3.75u l=0.4u
X3 vss.t76 ibias a_442_5111# vss.t107 sg13_hv_nmos ad=0.475p pd=2.88u as=0.475p ps=2.88u w=2.5u l=4u
X4 a_442_5111# a_442_5111# a_442_5111# vss.t3 sg13_hv_nmos ad=0.2375p pd=1.63u as=13.7666p ps=96.82u w=1.25u l=0.45u
X5 out a_1076_5541# vdd vdd sg13_hv_pmos ad=1.425p pd=7.88u as=1.425p ps=7.88u w=7.5u l=1u
X6 vss.t97 vss.t95 vss.t23 vss.t96 sg13_hv_nmos ad=0.85p pd=5.68u as=0 ps=0 w=2.5u l=0.45u
X7 ibias ibias vss.t103 vss.t105 sg13_hv_nmos ad=0.475p pd=2.88u as=0.475p ps=2.88u w=2.5u l=4u
X8 vdd vdd vdd vdd sg13_hv_pmos ad=0.7125p pd=4.13u as=0.18065n ps=0.47106m w=3.75u l=0.4u
X9 w_8388_2366# a_592_286# vdd vdd sg13_hv_pmos ad=1.425p pd=7.88u as=1.425p ps=7.88u w=7.5u l=4u
X10 a_9288_5041# inp w_8388_2366# w_8388_2366# sg13_hv_pmos ad=0.7125p pd=4.13u as=0.7125p ps=4.13u w=3.75u l=2u
X11 a_9288_5041# a_8488_4945# vss.t50 vss.t49 sg13_hv_nmos ad=0.2375p pd=1.63u as=0.2375p ps=1.63u w=1.25u l=4u
X12 a_592_2733# a_592_2733# vdd vdd sg13_hv_pmos ad=0.7125p pd=4.13u as=0.7125p ps=4.13u w=3.75u l=4u
X13 a_442_5111# a_442_5111# a_442_5111# vss.t5 sg13_hv_nmos ad=0.475p pd=2.88u as=0 ps=0 w=2.5u l=0.45u
X14 w_8388_2366# inn a_8488_4945# w_8388_2366# sg13_hv_pmos ad=0.7125p pd=4.13u as=0.7125p ps=4.13u w=3.75u l=2u
X15 w_8388_2366# a_3520_5051# vdd vdd sg13_hv_pmos ad=0.7125p pd=4.13u as=0.7125p ps=4.13u w=3.75u l=4u
X16 out.t0 a_9288_5041# vss.t25 vss.t26 sg13_hv_nmos ad=0.475p pd=2.88u as=0.475p ps=2.88u w=2.5u l=1u
X17 a_592_2733# inn a_442_5111# vss.t62 sg13_hv_nmos ad=0.2375p pd=1.63u as=0.2375p ps=1.63u w=1.25u l=2u
X18 a_12881_4979# a_14767_4615# vss.t64 rhigh l=9u w=1u
X19 w_8388_2366# w_8388_2366# w_8388_2366# w_8388_2366# sg13_hv_pmos ad=2.55p pd=15.68u as=0 ps=0 w=7.5u l=0.4u
X20 a_11355_6131# a_1392_382# a_1392_382# vss.t11 sg13_hv_nmos ad=0.475p pd=2.88u as=0.475p ps=2.88u w=2.5u l=1u
X21 a_442_5111# a_4818_4945# vss.t41 vss.t42 sg13_hv_nmos ad=0.2375p pd=1.63u as=0.2375p ps=1.63u w=1.25u l=4u
X22 a_8488_4945# inn w_8388_2366# w_8388_2366# sg13_hv_pmos ad=0.7125p pd=4.13u as=0.7125p ps=4.13u w=3.75u l=2u
X23 vss.t83 vss.t81 vss.t39 vss.t82 sg13_hv_nmos ad=0.425p pd=3.18u as=0 ps=0 w=1.25u l=0.45u
X24 vss.t34 vss.t34 vss.t33 rhigh l=9u w=1u
X25 a_1076_5541# a_592_2733# vdd vdd sg13_hv_pmos ad=0.7125p pd=4.13u as=0.7125p ps=4.13u w=3.75u l=4u
X26 vss.t21 vss.t77 vss.t7 vss.t78 sg13_hv_nmos ad=0.475p pd=2.88u as=0 ps=0 w=2.5u l=0.45u
X27 a_12881_4251# a_1076_5541# vss.t35 rhigh l=9u w=1u
X28 vdd vdd vdd vdd sg13_hv_pmos ad=1.275p pd=8.18u as=0 ps=0 w=3.75u l=0.4u
X29 a_9288_5041# a_8488_4945# vss.t53 vss.t54 sg13_hv_nmos ad=0.2375p pd=1.63u as=0.2375p ps=1.63u w=1.25u l=4u
X30 a_442_5111# a_592_286# a_3520_5051# vss.t1 sg13_hv_nmos ad=0.475p pd=2.88u as=0.475p ps=2.88u w=2.5u l=1u
X31 vss.t25 a_9288_5041# out.t0 vss.t24 sg13_hv_nmos ad=0.475p pd=2.88u as=0.475p ps=2.88u w=2.5u l=1u
X32 a_1076_5541# a_1076_5541# a_1076_5541# vdd sg13_hv_pmos ad=1.425p pd=7.88u as=34.7735p ps=0.10686m w=7.5u l=1u
X33 vdd a_592_286# a_5933_6071# vdd sg13_hv_pmos ad=1.425p pd=7.88u as=1.425p ps=7.88u w=7.5u l=4u
X34 a_12881_2795# a_14767_3159# vss.t69 rhigh l=9u w=1u
X35 a_442_5111# inn a_592_2733# vss.t61 sg13_hv_nmos ad=0.2375p pd=1.63u as=0.2375p ps=1.63u w=1.25u l=2u
X36 vdd a_1076_5541# out vdd sg13_hv_pmos ad=1.425p pd=7.88u as=1.425p ps=7.88u w=7.5u l=1u
X37 vss.t25 vss.t25 vss.t66 rhigh l=9u w=1u
X38 vss.t9 vss.t79 vss.t80 vss.t12 sg13_hv_nmos ad=0.475p pd=2.88u as=0 ps=0 w=2.5u l=0.45u
X39 vss.t103 ibias a_592_286# vss.t102 sg13_hv_nmos ad=0.475p pd=2.88u as=0.475p ps=2.88u w=2.5u l=4u
X40 vdd vdd vdd vdd sg13_hv_pmos ad=0.7125p pd=4.13u as=0 ps=0 w=3.75u l=0.4u
X41 vss.t16 a_5933_6071# a_5933_6071# vss.t18 sg13_hv_nmos ad=0.475p pd=2.88u as=0.475p ps=2.88u w=2.5u l=4u
X42 vdd a_592_2733# a_1076_5541# vdd sg13_hv_pmos ad=0.7125p pd=4.13u as=0.7125p ps=4.13u w=3.75u l=4u
X43 a_3520_5051# a_592_286# a_442_5111# vss.t0 sg13_hv_nmos ad=0.475p pd=2.88u as=0.475p ps=2.88u w=2.5u l=1u
X44 vdd a_592_2733# a_1076_5541# vdd sg13_hv_pmos ad=0.7125p pd=4.13u as=0.7125p ps=4.13u w=3.75u l=4u
X45 a_9508_346# a_9508_346# vdd vdd sg13_hv_pmos ad=1.425p pd=7.88u as=1.425p ps=7.88u w=7.5u l=1u
X46 vdd a_3520_5051# a_3520_5051# vdd sg13_hv_pmos ad=0.7125p pd=4.13u as=0.7125p ps=4.13u w=3.75u l=4u
X47 a_4818_4945# a_4818_4945# vss.t39 vss.t37 sg13_hv_nmos ad=0.2375p pd=1.63u as=0.2375p ps=1.63u w=1.25u l=4u
X48 a_442_5111# inp a_1076_5541# vss.t63 sg13_hv_nmos ad=0.2375p pd=1.63u as=0.2375p ps=1.63u w=1.25u l=2u
X49 vdd a_3520_5051# a_3520_5051# vdd sg13_hv_pmos ad=0.7125p pd=4.13u as=0.7125p ps=4.13u w=3.75u l=4u
X50 vdd vdd vdd vdd sg13_hv_pmos ad=2.55p pd=15.68u as=0 ps=0 w=7.5u l=0.4u
X51 vss.t41 a_4818_4945# a_4818_4945# vss.t40 sg13_hv_nmos ad=0.2375p pd=1.63u as=0.2375p ps=1.63u w=1.25u l=4u
X52 a_442_5111# ibias vss.t103 vss.t104 sg13_hv_nmos ad=0.475p pd=2.88u as=0.475p ps=2.88u w=2.5u l=4u
X53 w_8388_2366# a_3520_5051# vdd vdd sg13_hv_pmos ad=0.7125p pd=4.13u as=0.7125p ps=4.13u w=3.75u l=4u
X54 a_5933_6071# a_592_286# vdd vdd sg13_hv_pmos ad=1.425p pd=7.88u as=1.425p ps=7.88u w=7.5u l=4u
X55 a_1076_5541# a_592_286# vdd vdd sg13_hv_pmos ad=1.425p pd=7.88u as=1.425p ps=7.88u w=7.5u l=4u
X56 a_4818_4945# a_4818_4945# vss.t41 vss.t42 sg13_hv_nmos ad=0.2375p pd=1.63u as=0.2375p ps=1.63u w=1.25u l=4u
X57 a_442_5111# inp a_1076_5541# vss.t61 sg13_hv_nmos ad=0.2375p pd=1.63u as=0.2375p ps=1.63u w=1.25u l=2u
X58 vss.t90 vss.t88 vss.t38 vss.t82 sg13_hv_nmos ad=0.425p pd=3.18u as=0 ps=0 w=1.25u l=0.45u
X59 w_8388_2366# w_8388_2366# w_8388_2366# w_8388_2366# sg13_hv_pmos ad=0.7125p pd=4.13u as=0 ps=0 w=3.75u l=0.4u
X60 vss.t21 a_5933_6071# a_9288_5041# vss.t20 sg13_hv_nmos ad=0.475p pd=2.88u as=0.475p ps=2.88u w=2.5u l=4u
X61 vss.t56 vss.t53 vss.t87 vss.t86 sg13_hv_nmos ad=0.2375p pd=1.63u as=0 ps=0 w=1.25u l=0.45u
X62 vdd a_1076_5541# out vdd sg13_hv_pmos ad=1.425p pd=7.88u as=1.425p ps=7.88u w=7.5u l=1u
X63 vss.t44 vss.t84 vss.t51 vss.t85 sg13_hv_nmos ad=0.2375p pd=1.63u as=0 ps=0 w=1.25u l=0.45u
X64 a_9288_5041# a_9288_5041# a_9288_5041# vss.t12 sg13_hv_nmos ad=0.85p pd=5.68u as=17.3283p ps=85.93999u w=2.5u l=1u
X65 vdd vdd vdd vdd sg13_hv_pmos ad=1.425p pd=7.88u as=0 ps=0 w=7.5u l=0.4u
X66 a_9288_5041# a_9288_5041# a_9288_5041# vss.t12 sg13_hv_nmos ad=0.475p pd=2.88u as=0 ps=0 w=2.5u l=1u
X67 a_8488_4945# inn w_8388_2366# w_8388_2366# sg13_hv_pmos ad=0.7125p pd=4.13u as=0.7125p ps=4.13u w=3.75u l=2u
X68 a_8488_4945# a_8488_4945# vss.t53 vss.t54 sg13_hv_nmos ad=0.2375p pd=1.63u as=0.2375p ps=1.63u w=1.25u l=4u
X69 w_8388_2366# w_8388_2366# w_8388_2366# w_8388_2366# sg13_hv_pmos ad=1.275p pd=8.18u as=0 ps=0 w=3.75u l=0.4u
X70 vss.t73 vss.t70 vss.t72 vss.t71 sg13_hv_nmos ad=0.85p pd=5.68u as=0 ps=0 w=2.5u l=0.45u
X71 a_12881_3523# a_9288_5041# vss.t48 rhigh l=9u w=1u
X72 vdd a_592_286# a_1076_5541# vdd sg13_hv_pmos ad=1.425p pd=7.88u as=1.425p ps=7.88u w=7.5u l=4u
X73 a_592_2733# inn a_442_5111# vss.t60 sg13_hv_nmos ad=0.2375p pd=1.63u as=0.2375p ps=1.63u w=1.25u l=2u
X74 a_442_5111# inn a_592_2733# vss.t63 sg13_hv_nmos ad=0.2375p pd=1.63u as=0.2375p ps=1.63u w=1.25u l=2u
X75 a_1392_382# a_1392_382# a_11355_6131# vss.t10 sg13_hv_nmos ad=0.475p pd=2.88u as=0.475p ps=2.88u w=2.5u l=1u
X76 a_9288_5041# inp w_8388_2366# w_8388_2366# sg13_hv_pmos ad=0.7125p pd=4.13u as=0.7125p ps=4.13u w=3.75u l=2u
X77 vss.t16 a_5933_6071# a_6733_6167# vss.t15 sg13_hv_nmos ad=0.475p pd=2.88u as=0.475p ps=2.88u w=2.5u l=4u
X78 out.t0 a_9288_5041# vss.t23 vss.t22 sg13_hv_nmos ad=0.475p pd=2.88u as=0.475p ps=2.88u w=2.5u l=1u
X79 a_1076_5541# a_6733_6167# a_9288_5041# vdd sg13_hv_pmos ad=1.425p pd=7.88u as=1.425p ps=7.88u w=7.5u l=1u
X80 vdd a_9508_346# a_9508_346# vdd sg13_hv_pmos ad=1.425p pd=7.88u as=1.425p ps=7.88u w=7.5u l=1u
X81 a_12881_4251# a_14767_4615# vss.t65 rhigh l=9u w=1u
X82 a_5933_6071# a_5933_6071# vss.t16 vss.t17 sg13_hv_nmos ad=0.475p pd=2.88u as=0.475p ps=2.88u w=2.5u l=4u
X83 a_442_5111# a_442_5111# a_442_5111# vss.t2 sg13_hv_nmos ad=0.425p pd=3.18u as=0 ps=0 w=1.25u l=0.45u
X84 a_1076_5541# a_592_2733# vdd vdd sg13_hv_pmos ad=0.7125p pd=4.13u as=0.7125p ps=4.13u w=3.75u l=4u
X85 vss.t76 vss.t74 vss.t14 vss.t75 sg13_hv_nmos ad=0.475p pd=2.88u as=0 ps=0 w=2.5u l=0.45u
X86 vdd vdd vdd vdd sg13_hv_pmos ad=1.425p pd=7.88u as=0 ps=0 w=7.5u l=0.4u
X87 a_442_5111# a_4818_4945# vss.t38 vss.t37 sg13_hv_nmos ad=0.2375p pd=1.63u as=0.2375p ps=1.63u w=1.25u l=4u
X88 a_9508_346# a_6733_6167# a_6733_6167# vdd sg13_hv_pmos ad=1.425p pd=7.88u as=1.425p ps=7.88u w=7.5u l=1u
X89 vss.t103 ibias ibias vss.t106 sg13_hv_nmos ad=0.475p pd=2.88u as=0.475p ps=2.88u w=2.5u l=4u
X90 vss.t25 a_9288_5041# out.t0 vss.t29 sg13_hv_nmos ad=0.475p pd=2.88u as=0.475p ps=2.88u w=2.5u l=1u
X91 out a_1076_5541# vdd vdd sg13_hv_pmos ad=1.425p pd=7.88u as=1.425p ps=7.88u w=7.5u l=1u
X92 vss.t41 a_4818_4945# a_442_5111# vss.t40 sg13_hv_nmos ad=0.2375p pd=1.63u as=0.2375p ps=1.63u w=1.25u l=4u
X93 a_4818_4945# a_592_286# w_8388_2366# w_8388_2366# sg13_hv_pmos ad=1.425p pd=7.88u as=1.425p ps=7.88u w=7.5u l=1u
X94 a_11355_6131# a_11355_6131# vss.t7 vss.t6 sg13_hv_nmos ad=0.475p pd=2.88u as=0.475p ps=2.88u w=2.5u l=1u
X95 a_592_2733# a_592_2733# vdd vdd sg13_hv_pmos ad=0.7125p pd=4.13u as=0.7125p ps=4.13u w=3.75u l=4u
X96 vss.t9 a_11355_6131# a_11355_6131# vss.t8 sg13_hv_nmos ad=0.475p pd=2.88u as=0.475p ps=2.88u w=2.5u l=1u
X97 vss.t53 a_8488_4945# a_8488_4945# vss.t52 sg13_hv_nmos ad=0.2375p pd=1.63u as=0.2375p ps=1.63u w=1.25u l=4u
X98 a_9288_5041# a_6733_6167# a_1076_5541# vdd sg13_hv_pmos ad=1.425p pd=7.88u as=1.425p ps=7.88u w=7.5u l=1u
X99 vdd vdd vdd vdd sg13_hv_pmos ad=0.7125p pd=4.13u as=0 ps=0 w=3.75u l=0.4u
X100 vdd vdd vdd vdd sg13_hv_pmos ad=1.275p pd=8.18u as=0 ps=0 w=3.75u l=0.4u
X101 w_8388_2366# inn a_8488_4945# w_8388_2366# sg13_hv_pmos ad=0.7125p pd=4.13u as=0.7125p ps=4.13u w=3.75u l=2u
X102 vss.t44 a_4818_4945# a_442_5111# vss.t43 sg13_hv_nmos ad=0.2375p pd=1.63u as=0.2375p ps=1.63u w=1.25u l=4u
X103 a_1076_5541# inp a_442_5111# vss.t60 sg13_hv_nmos ad=0.2375p pd=1.63u as=0.2375p ps=1.63u w=1.25u l=2u
X104 vss.t59 vss.t53 vss.t94 vss.t86 sg13_hv_nmos ad=0.2375p pd=1.63u as=0 ps=0 w=1.25u l=0.45u
X105 a_1076_5541# a_1392_382# a_9288_5041# vss.t12 sg13_hv_nmos ad=0.475p pd=2.88u as=0.475p ps=2.88u w=2.5u l=1u
X106 a_3520_5051# a_3520_5051# vdd vdd sg13_hv_pmos ad=0.7125p pd=4.13u as=0.7125p ps=4.13u w=3.75u l=4u
X107 vss.t47 vss.t91 vss.t50 vss.t85 sg13_hv_nmos ad=0.2375p pd=1.63u as=0 ps=0 w=1.25u l=0.45u
X108 a_442_5111# a_442_5111# a_442_5111# vss.t2 sg13_hv_nmos ad=0.425p pd=3.18u as=0 ps=0 w=1.25u l=0.45u
X109 out.t0 a_9288_5041# vss.t25 vss.t28 sg13_hv_nmos ad=0.475p pd=2.88u as=0.475p ps=2.88u w=2.5u l=1u
X110 vdd a_592_286# w_8388_2366# vdd sg13_hv_pmos ad=1.425p pd=7.88u as=1.425p ps=7.88u w=7.5u l=4u
X111 vss.t56 a_8488_4945# a_9288_5041# vss.t55 sg13_hv_nmos ad=0.2375p pd=1.63u as=0.2375p ps=1.63u w=1.25u l=4u
X112 w_8388_2366# w_8388_2366# w_8388_2366# w_8388_2366# sg13_hv_pmos ad=1.425p pd=7.88u as=0 ps=0 w=7.5u l=0.4u
X113 vdd a_592_286# a_592_286# vdd sg13_hv_pmos ad=1.425p pd=7.88u as=1.425p ps=7.88u w=7.5u l=4u
X114 w_8388_2366# inp a_9288_5041# w_8388_2366# sg13_hv_pmos ad=0.7125p pd=4.13u as=0.7125p ps=4.13u w=3.75u l=2u
X115 vss.t25 a_9288_5041# out.t0 vss.t27 sg13_hv_nmos ad=0.475p pd=2.88u as=0.475p ps=2.88u w=2.5u l=1u
X116 vdd a_592_2733# a_592_2733# vdd sg13_hv_pmos ad=0.7125p pd=4.13u as=0.7125p ps=4.13u w=3.75u l=4u
X117 out a_1076_5541# vdd vdd sg13_hv_pmos ad=1.425p pd=7.88u as=1.425p ps=7.88u w=7.5u l=1u
X118 vdd a_3520_5051# w_8388_2366# vdd sg13_hv_pmos ad=0.7125p pd=4.13u as=0.7125p ps=4.13u w=3.75u l=4u
X119 a_9288_5041# a_1392_382# a_1076_5541# vss.t12 sg13_hv_nmos ad=0.475p pd=2.88u as=0.475p ps=2.88u w=2.5u l=1u
X120 a_1392_382# a_592_286# vdd vdd sg13_hv_pmos ad=1.425p pd=7.88u as=1.425p ps=7.88u w=7.5u l=4u
X121 w_8388_2366# w_8388_2366# w_8388_2366# w_8388_2366# sg13_hv_pmos ad=1.275p pd=8.18u as=0 ps=0 w=3.75u l=0.4u
X122 a_3520_5051# a_3520_5051# vdd vdd sg13_hv_pmos ad=0.7125p pd=4.13u as=0.7125p ps=4.13u w=3.75u l=4u
X123 a_12881_4979# a_14767_5343# vss.t36 rhigh l=9u w=1u
X124 a_9288_5041# a_5933_6071# vss.t16 vss.t19 sg13_hv_nmos ad=0.475p pd=2.88u as=0.475p ps=2.88u w=2.5u l=4u
X125 vdd a_1076_5541# out vdd sg13_hv_pmos ad=1.425p pd=7.88u as=1.425p ps=7.88u w=7.5u l=1u
X126 vss.t32 vss.t98 vss.t100 vss.t99 sg13_hv_nmos ad=0.475p pd=2.88u as=0 ps=0 w=2.5u l=0.45u
X127 a_12881_2795# a_14767_2795# vss.t67 rhigh l=9u w=1u
X128 w_8388_2366# a_592_286# a_4818_4945# w_8388_2366# sg13_hv_pmos ad=1.425p pd=7.88u as=1.425p ps=7.88u w=7.5u l=1u
X129 a_8488_4945# a_8488_4945# vss.t51 vss.t49 sg13_hv_nmos ad=0.2375p pd=1.63u as=0.2375p ps=1.63u w=1.25u l=4u
X130 vdd vdd vdd vdd sg13_hv_pmos ad=0.7125p pd=4.13u as=0 ps=0 w=3.75u l=0.4u
X131 vdd a_592_2733# a_592_2733# vdd sg13_hv_pmos ad=0.7125p pd=4.13u as=0.7125p ps=4.13u w=3.75u l=4u
X132 vss.t53 a_8488_4945# a_9288_5041# vss.t52 sg13_hv_nmos ad=0.2375p pd=1.63u as=0.2375p ps=1.63u w=1.25u l=4u
X133 a_12881_3523# a_14767_3159# vss.t68 rhigh l=9u w=1u
X134 vdd a_3520_5051# w_8388_2366# vdd sg13_hv_pmos ad=0.7125p pd=4.13u as=0.7125p ps=4.13u w=3.75u l=4u
X135 a_442_5111# a_442_5111# a_442_5111# vss.t4 sg13_hv_nmos ad=0.85p pd=5.68u as=0 ps=0 w=2.5u l=0.45u
X136 vdd vdd vdd vdd sg13_hv_pmos ad=2.55p pd=15.68u as=0 ps=0 w=7.5u l=0.4u
X137 a_592_286# a_592_286# vdd vdd sg13_hv_pmos ad=1.425p pd=7.88u as=1.425p ps=7.88u w=7.5u l=4u
X138 vss.t47 a_4818_4945# a_4818_4945# vss.t43 sg13_hv_nmos ad=0.2375p pd=1.63u as=0.2375p ps=1.63u w=1.25u l=4u
X139 a_442_5111# a_442_5111# a_442_5111# vss.t3 sg13_hv_nmos ad=0.2375p pd=1.63u as=0 ps=0 w=1.25u l=0.45u
X140 vdd vdd vdd vdd sg13_hv_pmos ad=1.425p pd=7.88u as=0 ps=0 w=7.5u l=0.4u
X141 a_592_286# ibias vss.t72 vss.t101 sg13_hv_nmos ad=0.475p pd=2.88u as=0.475p ps=2.88u w=2.5u l=4u
X142 vss.t32 a_9288_5041# out.t1 vss.t31 sg13_hv_nmos ad=0.475p pd=2.88u as=0.475p ps=2.88u w=2.5u l=1u
X143 out a_1076_5541# vdd vdd sg13_hv_pmos ad=1.425p pd=7.88u as=1.425p ps=7.88u w=7.5u l=1u
X144 a_1076_5541# a_1076_5541# a_1076_5541# vdd sg13_hv_pmos ad=2.55p pd=15.68u as=0 ps=0 w=7.5u l=1u
X145 vss.t59 a_8488_4945# a_8488_4945# vss.t55 sg13_hv_nmos ad=0.2375p pd=1.63u as=0.2375p ps=1.63u w=1.25u l=4u
X146 a_1076_5541# inp a_442_5111# vss.t62 sg13_hv_nmos ad=0.2375p pd=1.63u as=0.2375p ps=1.63u w=1.25u l=2u
X147 a_6733_6167# a_6733_6167# a_9508_346# vdd sg13_hv_pmos ad=1.425p pd=7.88u as=1.425p ps=7.88u w=7.5u l=1u
X148 w_8388_2366# inp a_9288_5041# w_8388_2366# sg13_hv_pmos ad=0.7125p pd=4.13u as=0.7125p ps=4.13u w=3.75u l=2u
X149 a_6733_6167# a_5933_6071# vss.t14 vss.t13 sg13_hv_nmos ad=0.475p pd=2.88u as=0.475p ps=2.88u w=2.5u l=4u
X150 vdd a_1076_5541# out vdd sg13_hv_pmos ad=1.425p pd=7.88u as=1.425p ps=7.88u w=7.5u l=1u
C0 a_12967_4251# a_1076_5541# 0.19604f
C1 a_9508_346# w_8388_2366# 0.01462f
C2 a_12967_3159# a_9288_5041# 0.04099f
C3 a_8488_4945# a_5933_6071# 1.42862f
C4 a_12967_3159# a_12967_2795# 0.20927f
C5 vdd a_5933_6071# 0.79989f
C6 out a_14767_5343# 0.33471p
C7 a_12967_3523# a_14767_2795# 0.04329f
C8 a_14767_4615# a_12967_4615# 0.03876f
C9 a_12967_2795# a_9288_5041# 0.04495f
C10 w_8388_2366# a_4818_4945# 0.54521f
C11 inn a_5933_6071# 0.02645f
C12 a_5933_6071# a_1392_382# 0.07674f
C13 inp a_3520_5051# 0.11543f
C14 a_12967_4615# a_12967_4251# 0.20927f
C15 ibias inp 0.16028f
C16 a_14767_5343# a_1076_5541# 0.08664f
C17 ibias a_3520_5051# 0.01869f
C18 a_6733_6167# a_5933_6071# 2.25971f
C19 a_442_5111# w_8388_2366# 0.01993f
C20 a_8488_4945# inp 0.6188f
C21 a_12967_5343# a_1076_5541# 0.04008f
C22 inp vdd 0.12326f
C23 vdd a_3520_5051# 20.341f
C24 a_12967_3159# a_14767_2795# 0.04329f
C25 a_9288_5041# a_12967_5707# 0.02198f
C26 a_12967_4251# a_12967_3887# 0.20927f
C27 inp a_1392_382# 0.20624f
C28 inn inp 5.07118f
C29 inn a_3520_5051# 0.41738f
C30 a_1392_382# a_3520_5051# 0.18479f
C31 inn ibias 0.12725f
C32 a_14767_2795# a_9288_5041# 1.0758f
C33 a_12967_4615# a_14767_5343# 0.04329f
C34 a_5933_6071# a_592_286# 1.18671f
C35 a_6733_6167# inp 0.04296f
C36 a_12967_2795# a_14767_2795# 0.08145f
C37 a_6733_6167# a_3520_5051# 0.12248f
C38 a_12967_4979# a_1076_5541# 0.04703f
C39 a_8488_4945# inn 1.31946f
C40 a_8488_4945# a_1392_382# 0.3486f
C41 a_5933_6071# a_1076_5541# 0.13572f
C42 a_592_2733# inp 0.31895f
C43 inn vdd 0.30448f
C44 vdd a_1392_382# 2.12514f
C45 a_592_2733# a_3520_5051# 0.11013f
C46 a_592_2733# ibias 0.04618f
C47 inn a_1392_382# 0.1848f
C48 a_6733_6167# vdd 3.98013f
C49 inp a_592_286# 0.43322f
C50 a_592_286# a_3520_5051# 0.37968f
C51 a_6733_6167# inn 0.0433f
C52 a_6733_6167# a_1392_382# 0.636f
C53 ibias a_592_286# 0.80911f
C54 a_12967_4615# a_12967_4979# 0.20927f
C55 a_592_2733# vdd 19.8957f
C56 a_12967_3523# a_14767_3159# 0.03876f
C57 inp a_1076_5541# 0.6563f
C58 a_12967_4251# a_9288_5041# 0.01473f
C59 a_592_2733# inn 1.36419f
C60 a_592_2733# a_1392_382# 0.08807f
C61 a_8488_4945# a_592_286# 0.09532f
C62 a_3520_5051# a_1076_5541# 0.20675f
C63 out vdd 2.11845f
C64 vdd a_592_286# 39.8003f
C65 a_12881_4979# a_12967_5343# 0.03876f
C66 a_12881_2795# a_1076_5541# 0.02347f
C67 inn a_592_286# 0.18492f
C68 a_1392_382# a_592_286# 1.91613f
C69 vdd a_1076_5541# 16.4562f
C70 w_8388_2366# a_5933_6071# 0.43298f
C71 a_11355_6131# a_9288_5041# 0.08475f
C72 a_14767_3159# a_12967_3159# 0.03876f
C73 a_6733_6167# a_592_286# 0.08698f
C74 inn a_1076_5541# 0.39797f
C75 a_12881_2795# a_12881_3523# 0.01672f
C76 a_1392_382# a_1076_5541# 1.88462f
C77 a_9288_5041# a_14767_5343# 0.04052f
C78 a_14767_3159# a_9288_5041# 0.02632f
C79 a_12881_4979# a_12967_4979# 0.03876f
C80 a_592_2733# a_592_286# 0.62365f
C81 a_442_5111# a_4818_4945# 1.04724f
C82 a_6733_6167# a_1076_5541# 1.62117f
C83 a_12881_4251# a_1076_5541# 0.04323f
C84 a_592_2733# a_1076_5541# 3.45441f
C85 w_8388_2366# inp 6.12256f
C86 a_12967_2431# a_1076_5541# 0.09942f
C87 w_8388_2366# a_3520_5051# 1.95611f
C88 a_14767_5343# a_12967_5707# 0.04289f
C89 out a_1076_5541# 2.50637f
C90 a_12881_2795# w_8388_2366# 0.03879f
C91 a_592_286# a_1076_5541# 1.93392f
C92 a_12881_4251# a_12881_3523# 0.01672f
C93 a_8488_4945# w_8388_2366# 1.83939f
C94 a_12967_5343# a_12967_5707# 0.20927f
C95 w_8388_2366# vdd 1.65987f
C96 a_9288_5041# a_5933_6071# 0.61977f
C97 a_14767_3159# a_14767_2795# 0.1032f
C98 a_12881_4251# a_12967_4615# 0.03876f
C99 w_8388_2366# inn 6.13335f
C100 w_8388_2366# a_1392_382# 1.34032f
C101 a_6733_6167# w_8388_2366# 0.34064f
C102 a_12881_3523# a_1076_5541# 0.02244f
C103 w_8388_2366# a_12881_4251# 0.04f
C104 inp a_9288_5041# 1.40218f
C105 a_12881_2795# a_12967_3159# 0.03876f
C106 a_12967_4615# a_1076_5541# 0.06311f
C107 a_14767_4615# a_14767_5343# 0.10346f
C108 a_12967_4251# a_14767_5343# 0.01305f
C109 a_8488_4945# a_9288_5041# 1.38579f
C110 w_8388_2366# a_592_286# 3.48603f
C111 a_12881_2795# a_12967_2795# 0.03876f
C112 a_12881_4251# a_12881_4979# 0.01672f
C113 vdd a_9288_5041# 0.66411f
C114 a_5933_6071# a_4818_4945# 1.14036f
C115 a_12967_3887# a_1076_5541# 0.03091f
C116 w_8388_2366# a_1076_5541# 0.18098f
C117 inn a_9288_5041# 0.32254f
C118 a_9288_5041# a_1392_382# 1.22566f
C119 a_9508_346# inp 0.01072f
C120 a_442_5111# a_5933_6071# 0.06572f
C121 a_12967_3523# a_1076_5541# 0.02011f
C122 a_6733_6167# a_9288_5041# 0.62999f
C123 a_14767_4615# a_12967_4979# 0.03876f
C124 w_8388_2366# a_12881_3523# 0.04192f
C125 a_12881_3523# a_12967_3887# 0.03876f
C126 a_12881_4979# a_1076_5541# 0.02632f
C127 inp a_4818_4945# 0.23197f
C128 a_9508_346# vdd 2.73634f
C129 a_12967_5343# a_14767_5343# 0.08145f
C130 a_12967_2431# a_9288_5041# 0.01328f
C131 a_12967_3523# a_12881_3523# 0.03876f
C132 a_3520_5051# a_4818_4945# 0.78505f
C133 ibias a_4818_4945# 0.44789f
C134 a_12967_2431# a_12967_2795# 0.20927f
C135 a_1392_382# a_12967_5707# 0.05833f
C136 a_14767_2795# vdd 0.31715f
C137 out a_9288_5041# 1.36469f
C138 a_12967_3159# a_1076_5541# 0.02269f
C139 a_442_5111# inp 0.95508f
C140 a_8488_4945# a_4818_4945# 0.28196f
C141 a_442_5111# a_3520_5051# 0.44282f
C142 a_442_5111# ibias 0.83126f
C143 a_9508_346# a_6733_6167# 1.06577f
C144 vdd a_4818_4945# 0.15626f
C145 a_9288_5041# a_1076_5541# 3.56717f
C146 a_14767_5343# a_12967_4979# 0.04329f
C147 a_12967_2795# a_1076_5541# 0.02684f
C148 inn a_4818_4945# 0.02908f
C149 a_442_5111# vdd 0.03377f
C150 a_12967_5343# a_12967_4979# 0.20927f
C151 a_12967_3523# a_12967_3887# 0.20927f
C152 a_6733_6167# a_4818_4945# 0.30974f
C153 a_9288_5041# a_12881_3523# 0.02692f
C154 a_12967_2431# a_14767_2795# 0.0255f
C155 a_442_5111# inn 0.97231f
C156 a_9508_346# a_592_286# 0.04283f
C157 out a_14767_2795# 0.33643p
C158 a_442_5111# a_6733_6167# 0.01655f
C159 a_9508_346# a_1076_5541# 0.0855f
C160 a_14767_2795# a_1076_5541# 0.08049f
C161 a_442_5111# a_592_2733# 0.34884f
C162 a_592_286# a_4818_4945# 0.57749f
C163 a_8488_4945# a_11355_6131# 0.05561f
C164 w_8388_2366# a_9288_5041# 1.17037f
C165 a_9288_5041# a_12967_3887# 0.17703f
C166 a_12881_4251# a_12967_4251# 0.03876f
C167 a_12967_3523# a_12967_3159# 0.20927f
C168 a_442_5111# a_592_286# 0.77885f
C169 a_11355_6131# a_1392_382# 0.61898f
C170 a_12967_3523# a_9288_5041# 0.05266f
C171 a_442_5111# a_1076_5541# 0.26405f
C172 a_14767_4615# a_1076_5541# 0.02542f
C173 inp a_5933_6071# 0.07536f
R0 out.t0 out.t1 3.11994
R1 out out.t0 1.21737
R2 vss.n358 vss.n54 55358.3
R3 vss.n24 vss.n45 0.0315273
R4 vss.t96 vss.n49 22.0289
R5 vss.n46 vss.t5 17.3475
R6 vss.t86 vss.n249 96.1966
R7 vss.n162 vss.n161 93.268
R8 vss.t31 vss.n53 92.6702
R9 vss.n375 vss.t30 88.8232
R10 vss.t1 vss.n165 85.7681
R11 vss.n374 vss.n373 85.2665
R12 vss.n249 vss.t8 85.107
R13 vss.n376 vss.t29 82.9002
R14 vss.t0 vss.n163 82.4923
R15 vss.n313 vss.n312 80.4072
R16 vss.n311 vss.n310 80.4072
R17 vss.n309 vss.n308 80.4072
R18 vss.n307 vss.n306 80.4072
R19 vss.n305 vss.n304 80.4072
R20 vss.n303 vss.n302 80.4072
R21 vss.n301 vss.n300 80.4072
R22 vss.n299 vss.n298 80.4072
R23 vss.n297 vss.n296 80.4072
R24 vss.n295 vss.n294 80.4072
R25 vss.n293 vss.n292 80.4072
R26 vss.n287 vss.n286 80.4072
R27 vss.n285 vss.n284 80.4072
R28 vss.n283 vss.n282 80.4072
R29 vss.n281 vss.n280 80.4072
R30 vss.n279 vss.n278 80.4072
R31 vss.n277 vss.n276 80.4072
R32 vss.n275 vss.n274 80.4072
R33 vss.n271 vss.n270 80.4072
R34 vss.n269 vss.n268 80.4072
R35 vss.n263 vss.n262 80.4072
R36 vss.n261 vss.n260 80.4072
R37 vss.n257 vss.n256 80.4072
R38 vss.n255 vss.n254 80.4072
R39 vss.n253 vss.n252 80.4072
R40 vss.n124 vss.n123 78.7062
R41 vss.n122 vss.n121 78.7062
R42 vss.n116 vss.n115 78.7062
R43 vss.n114 vss.n113 78.7062
R44 vss.n112 vss.n111 78.7062
R45 vss.n110 vss.n109 78.7062
R46 vss.n108 vss.n107 78.7062
R47 vss.n106 vss.n105 78.7062
R48 vss.n102 vss.n101 78.7062
R49 vss.n100 vss.n99 78.7062
R50 vss.n98 vss.n97 78.7062
R51 vss.n96 vss.n95 78.7062
R52 vss.n92 vss.n91 78.7062
R53 vss.n90 vss.n89 78.7062
R54 vss.n88 vss.n87 78.7062
R55 vss.t22 vss.n380 76.9772
R56 vss.n377 vss.t28 76.9772
R57 vss.t24 vss.n379 71.0542
R58 vss.n378 vss.t27 71.0542
R59 vss.t26 vss.n378 65.1312
R60 vss.n379 vss.t26 65.1312
R61 vss.t78 vss.n272 63.7713
R62 vss.n25 vss.n24 8.88535
R63 vss.t4 vss.n162 60.4759
R64 vss.n315 vss.t19 59.6123
R65 vss.t27 vss.n377 59.2082
R66 vss.n380 vss.t24 59.2082
R67 vss.t106 vss.n164 58.2211
R68 vss.t60 vss.n117 57.718
R69 vss.t61 vss.n103 57.718
R70 vss.n163 vss.t4 57.5678
R71 vss.n120 vss.t102 56.4063
R72 vss.n165 vss.t106 55.5976
R73 vss.t28 vss.n376 53.2852
R74 vss.n49 vss.t22 53.2619
R75 vss.n29 vss.n160 10.1978
R76 vss.n157 vss.n156 52.471
R77 vss.n155 vss.n154 52.471
R78 vss.n153 vss.n152 52.471
R79 vss.n151 vss.n150 52.471
R80 vss.n149 vss.n148 52.471
R81 vss.n147 vss.n146 52.471
R82 vss.n143 vss.n142 52.471
R83 vss.n141 vss.n140 52.471
R84 vss.n139 vss.n138 52.471
R85 vss.n137 vss.n136 52.471
R86 vss.n135 vss.n134 52.471
R87 vss.n133 vss.n132 52.471
R88 vss.n129 vss.n128 52.471
R89 vss.n127 vss.n126 52.471
R90 vss.n251 vss.t11 51.2944
R91 vss.t104 vss.n24 28.8749
R92 vss.t55 vss.n264 49.9081
R93 vss.n126 vss.n125 49.0388
R94 vss.n289 vss.t20 48.5218
R95 vss.t29 vss.n375 47.3622
R96 vss.n166 vss.n25 52.9475
R97 vss.n175 vss.n174 47.2239
R98 vss.n173 vss.n86 47.2239
R99 vss.n178 vss.n177 47.2239
R100 vss.n176 vss.n85 47.2239
R101 vss.n181 vss.n180 47.2239
R102 vss.n179 vss.n84 47.2239
R103 vss.n187 vss.n186 47.2239
R104 vss.n185 vss.n82 47.2239
R105 vss.n190 vss.n189 47.2239
R106 vss.n188 vss.n81 47.2239
R107 vss.n193 vss.n192 47.2239
R108 vss.n191 vss.n80 47.2239
R109 vss.n196 vss.n195 47.2239
R110 vss.n194 vss.n79 47.2239
R111 vss.n199 vss.n198 47.2239
R112 vss.n197 vss.n78 47.2239
R113 vss.n202 vss.n201 47.2239
R114 vss.n205 vss.n204 47.2239
R115 vss.n203 vss.n76 47.2239
R116 vss.n208 vss.n207 47.2239
R117 vss.n206 vss.n75 47.2239
R118 vss.n211 vss.n210 47.2239
R119 vss.n209 vss.n74 47.2239
R120 vss.n214 vss.n213 47.2239
R121 vss.n212 vss.n73 47.2239
R122 vss.n217 vss.n216 47.2239
R123 vss.n215 vss.n72 47.2239
R124 vss.n220 vss.n219 47.2239
R125 vss.n218 vss.n71 47.2239
R126 vss.n223 vss.n222 47.2239
R127 vss.n221 vss.n70 47.2239
R128 vss.n226 vss.n225 47.2239
R129 vss.n229 vss.n228 47.2239
R130 vss.n227 vss.n68 47.2239
R131 vss.n232 vss.n231 47.2239
R132 vss.n230 vss.n67 47.2239
R133 vss.n235 vss.n234 47.2239
R134 vss.n233 vss.n66 47.2239
R135 vss.n238 vss.n237 47.2239
R136 vss.n236 vss.n65 47.2239
R137 vss.n241 vss.n240 47.2239
R138 vss.n239 vss.n64 47.2239
R139 vss.n367 vss.n366 47.2239
R140 vss.n365 vss.n364 47.2239
R141 vss.n361 vss.n360 47.2239
R142 vss.n244 vss.n243 47.2239
R143 vss.n357 vss.n356 47.1354
R144 vss.n357 vss.n354 47.1354
R145 vss.n354 vss.n353 47.1354
R146 vss.n353 vss.n352 47.1354
R147 vss.n352 vss.n351 47.1354
R148 vss.n351 vss.n350 47.1354
R149 vss.n350 vss.n349 47.1354
R150 vss.n349 vss.n348 47.1354
R151 vss.n348 vss.n347 47.1354
R152 vss.n347 vss.n346 47.1354
R153 vss.n346 vss.n345 47.1354
R154 vss.n345 vss.n344 47.1354
R155 vss.n344 vss.n343 47.1354
R156 vss.n343 vss.n342 47.1354
R157 vss.n341 vss.n340 47.1354
R158 vss.n339 vss.n338 47.1354
R159 vss.n338 vss.n337 47.1354
R160 vss.n337 vss.n336 47.1354
R161 vss.n336 vss.n335 47.1354
R162 vss.n335 vss.n334 47.1354
R163 vss.n334 vss.n333 47.1354
R164 vss.n333 vss.n332 47.1354
R165 vss.n332 vss.n331 47.1354
R166 vss.n331 vss.n330 47.1354
R167 vss.n330 vss.n329 47.1354
R168 vss.n329 vss.n328 47.1354
R169 vss.n328 vss.n327 47.1354
R170 vss.n327 vss.n326 47.1354
R171 vss.n326 vss.n325 47.1354
R172 vss.n325 vss.n324 47.1354
R173 vss.n324 vss.n323 47.1354
R174 vss.n323 vss.n322 47.1354
R175 vss.n322 vss.n321 47.1354
R176 vss.n321 vss.n320 47.1354
R177 vss.n320 vss.n319 47.1354
R178 vss.n319 vss.n318 47.1354
R179 vss.n318 vss.n317 47.1354
R180 vss.n317 vss.n316 47.1354
R181 vss.n94 vss.t105 45.9122
R182 vss.t85 vss.n355 45.9122
R183 vss.n259 vss.t10 45.7491
R184 vss.n356 vss.t85 44.1834
R185 vss.n224 vss.t15 43.2887
R186 vss.n248 vss.n247 42.1311
R187 vss.n174 vss.n166 41.9769
R188 vss.n175 vss.n173 41.9769
R189 vss.n177 vss.n86 41.9769
R190 vss.n178 vss.n176 41.9769
R191 vss.n180 vss.n85 41.9769
R192 vss.n181 vss.n179 41.9769
R193 vss.n183 vss.n84 41.9769
R194 vss.n184 vss.n182 41.9769
R195 vss.n186 vss.n83 41.9769
R196 vss.n187 vss.n185 41.9769
R197 vss.n189 vss.n82 41.9769
R198 vss.n190 vss.n188 41.9769
R199 vss.n192 vss.n81 41.9769
R200 vss.n193 vss.n191 41.9769
R201 vss.n195 vss.n80 41.9769
R202 vss.n198 vss.n79 41.9769
R203 vss.n199 vss.n197 41.9769
R204 vss.n201 vss.n78 41.9769
R205 vss.n202 vss.n200 41.9769
R206 vss.n204 vss.n77 41.9769
R207 vss.n205 vss.n203 41.9769
R208 vss.n207 vss.n76 41.9769
R209 vss.n210 vss.n75 41.9769
R210 vss.n211 vss.n209 41.9769
R211 vss.n213 vss.n74 41.9769
R212 vss.n214 vss.n212 41.9769
R213 vss.n216 vss.n73 41.9769
R214 vss.n217 vss.n215 41.9769
R215 vss.n219 vss.n72 41.9769
R216 vss.n220 vss.n218 41.9769
R217 vss.n223 vss.n221 41.9769
R218 vss.n225 vss.n70 41.9769
R219 vss.n226 vss.n224 41.9769
R220 vss.n228 vss.n69 41.9769
R221 vss.n229 vss.n227 41.9769
R222 vss.n231 vss.n68 41.9769
R223 vss.n232 vss.n230 41.9769
R224 vss.n234 vss.n67 41.9769
R225 vss.n235 vss.n233 41.9769
R226 vss.n237 vss.n66 41.9769
R227 vss.n238 vss.n236 41.9769
R228 vss.n240 vss.n65 41.9769
R229 vss.n366 vss.n64 41.9769
R230 vss.n367 vss.n365 41.9769
R231 vss.n364 vss.n363 41.9769
R232 vss.n362 vss.n361 41.9769
R233 vss.n360 vss.n359 41.9769
R234 vss.n243 vss.n242 41.9769
R235 vss.n355 vss.n244 41.9769
R236 vss.t52 vss.n315 41.5901
R237 vss.n291 vss.t54 41.5901
R238 vss.n373 vss.n53 40.844
R239 vss.n25 vss.t82 21.2527
R240 vss.n267 vss.t6 40.2038
R241 vss.t6 vss.n266 40.2038
R242 vss.t30 vss.n374 39.3632
R243 vss.t40 vss.n77 39.3534
R244 vss.t42 vss.n71 39.3534
R245 vss.n37 vss.t67 39.0202
R246 vss.n34 vss.t48 39.0202
R247 vss.t54 vss.n290 38.8175
R248 vss.t8 vss.n248 37.9711
R249 vss.n31 vss.t64 37.348
R250 vss.n29 vss.n24 22.3108
R251 vss.n160 vss.n159 36.7298
R252 vss.n158 vss.n157 36.7298
R253 vss.n156 vss.n155 36.7298
R254 vss.n152 vss.n151 36.7298
R255 vss.n150 vss.n149 36.7298
R256 vss.n148 vss.n147 36.7298
R257 vss.n146 vss.n145 36.7298
R258 vss.n142 vss.n141 36.7298
R259 vss.n140 vss.n139 36.7298
R260 vss.n138 vss.n137 36.7298
R261 vss.n136 vss.n135 36.7298
R262 vss.n134 vss.n133 36.7298
R263 vss.n132 vss.n131 36.7298
R264 vss.n130 vss.n129 36.7298
R265 vss.n128 vss.n127 36.7298
R266 vss.n196 vss.t75 36.7298
R267 vss.n45 vss.t31 35.522
R268 vss.t13 vss.n206 35.4181
R269 vss.t33 vss.n30 34.8424
R270 vss.t10 vss.n258 34.6585
R271 vss.t71 vss.n158 34.1063
R272 vss.n44 vss.t12 11.8735
R273 vss.n164 vss.t0 33.2976
R274 vss.t65 vss.n33 33.1702
R275 vss.t2 vss.n153 32.7946
R276 vss.t105 vss.n93 32.7946
R277 vss.n363 vss.t17 32.7946
R278 vss.t20 vss.n288 31.8859
R279 vss.t68 vss.n36 31.514
R280 vss.t66 vss.n39 31.4979
R281 vss.n145 vss.t62 31.4828
R282 vss.n131 vss.t63 31.4828
R283 vss.n358 vss.n242 31.4828
R284 vss.t49 vss.n341 30.4996
R285 vss.n265 vss.t55 30.4996
R286 vss.t11 vss.n250 29.1133
R287 vss.n36 vss.t69 28.9915
R288 vss.n33 vss.t35 28.9868
R289 vss.n184 vss.t37 28.8593
R290 vss.n241 vss.t43 28.8593
R291 vss.n372 vss.n54 28.1986
R292 vss.n24 vss.n49 0.060606
R293 vss.n30 vss.t36 27.3145
R294 vss.n144 vss.t101 24.924
R295 vss.n182 vss.t107 24.924
R296 vss.t36 vss.n31 24.809
R297 vss.n340 vss.t18 23.568
R298 vss.t18 vss.n339 23.568
R299 vss.t69 vss.n37 23.1367
R300 vss.t35 vss.n34 23.1367
R301 vss.n125 vss.n124 22.8035
R302 vss.n39 vss.n54 22.7159
R303 vss.t102 vss.n119 22.3005
R304 vss.t107 vss.n83 22.3005
R305 vss.n46 vss.t1 30.3123
R306 vss.t62 vss.n144 20.9887
R307 vss.t63 vss.n130 20.9887
R308 vss.n118 vss.t60 20.9887
R309 vss.n104 vss.t61 20.9887
R310 vss.t19 vss.n314 20.7953
R311 vss.n38 vss.t66 20.7093
R312 vss.n35 vss.t68 20.7093
R313 vss.t99 vss.n45 16.3868
R314 vss.n32 vss.t65 19.0371
R315 vss.n159 vss.t71 18.3652
R316 vss.t37 vss.n183 18.3652
R317 vss.n44 vss.n40 0.0135612
R318 vss.n24 vss.n21 0.324744
R319 vss.n7 vss.n27 0.0563104
R320 vss.n27 vss.n24 4.24292
R321 vss.n24 vss.n18 3.39128
R322 vss.n18 vss.n5 0.0101308
R323 vss.n41 vss.n18 0.0538401
R324 vss.n24 vss.n42 5.65806
R325 vss.n26 vss.n24 1.23648
R326 vss.n23 vss.n20 0.0553637
R327 vss.n20 vss.n7 3.38114
R328 vss.n7 vss.n6 0.0305143
R329 vss.n19 vss.n5 8.49621
R330 vss.n42 vss.n41 0.0282844
R331 vss.n41 vss.n19 5.66008
R332 vss.n43 vss.n19 8.49621
R333 vss.n1 vss.t44 17.0005
R334 vss.t84 vss.t51 17.0005
R335 vss.n63 vss.n2 0.862651
R336 vss.t47 vss.t91 17.0005
R337 vss.n0 vss.n3 0.139689
R338 vss.t59 vss.t53 5.55285
R339 vss.t53 vss.t94 5.55689
R340 vss.n356 vss.n24 17.0005
R341 vss.n354 vss.n24 17.0005
R342 vss.n352 vss.n24 17.0005
R343 vss.n350 vss.n24 17.0005
R344 vss.n348 vss.n24 17.0005
R345 vss.n346 vss.n24 17.0005
R346 vss.n344 vss.n24 17.0005
R347 vss.n342 vss.n24 17.0005
R348 vss.n340 vss.n24 17.0005
R349 vss.n338 vss.n24 17.0005
R350 vss.n336 vss.n24 17.0005
R351 vss.n334 vss.n24 17.0005
R352 vss.n332 vss.n24 17.0005
R353 vss.n330 vss.n24 17.0005
R354 vss.n328 vss.n24 17.0005
R355 vss.n326 vss.n24 17.0005
R356 vss.n324 vss.n24 17.0005
R357 vss.n322 vss.n24 17.0005
R358 vss.n320 vss.n24 17.0005
R359 vss.n318 vss.n24 17.0005
R360 vss.n316 vss.n24 17.0005
R361 vss.n314 vss.n24 17.0005
R362 vss.n312 vss.n24 17.0005
R363 vss.n310 vss.n24 17.0005
R364 vss.n308 vss.n24 17.0005
R365 vss.n306 vss.n24 17.0005
R366 vss.n304 vss.n24 17.0005
R367 vss.n302 vss.n24 17.0005
R368 vss.n300 vss.n24 17.0005
R369 vss.n298 vss.n24 17.0005
R370 vss.n296 vss.n24 17.0005
R371 vss.n294 vss.n24 17.0005
R372 vss.n292 vss.n24 17.0005
R373 vss.n290 vss.n24 17.0005
R374 vss.n288 vss.n24 17.0005
R375 vss.n286 vss.n24 17.0005
R376 vss.n284 vss.n24 17.0005
R377 vss.n282 vss.n24 17.0005
R378 vss.n280 vss.n24 17.0005
R379 vss.n278 vss.n24 17.0005
R380 vss.n276 vss.n24 17.0005
R381 vss.n274 vss.n24 17.0005
R382 vss.n272 vss.n24 17.0005
R383 vss.n270 vss.n24 17.0005
R384 vss.n268 vss.n24 17.0005
R385 vss.n266 vss.n24 17.0005
R386 vss.n264 vss.n24 17.0005
R387 vss.n262 vss.n24 17.0005
R388 vss.n260 vss.n24 17.0005
R389 vss.n258 vss.n24 17.0005
R390 vss.n256 vss.n24 17.0005
R391 vss.n254 vss.n24 17.0005
R392 vss.n252 vss.n24 17.0005
R393 vss.n250 vss.n24 17.0005
R394 vss.n159 vss.n24 17.0005
R395 vss.n157 vss.n24 17.0005
R396 vss.n155 vss.n24 17.0005
R397 vss.n153 vss.n24 17.0005
R398 vss.n151 vss.n24 17.0005
R399 vss.n149 vss.n24 17.0005
R400 vss.n147 vss.n24 17.0005
R401 vss.n145 vss.n24 17.0005
R402 vss.n143 vss.n24 17.0005
R403 vss.n141 vss.n24 17.0005
R404 vss.n139 vss.n24 17.0005
R405 vss.n137 vss.n24 17.0005
R406 vss.n135 vss.n24 17.0005
R407 vss.n133 vss.n24 17.0005
R408 vss.n131 vss.n24 17.0005
R409 vss.n129 vss.n24 17.0005
R410 vss.n127 vss.n24 17.0005
R411 vss.n123 vss.n24 17.0005
R412 vss.n121 vss.n24 17.0005
R413 vss.n119 vss.n24 17.0005
R414 vss.n117 vss.n24 17.0005
R415 vss.n115 vss.n24 17.0005
R416 vss.n113 vss.n24 17.0005
R417 vss.n111 vss.n24 17.0005
R418 vss.n109 vss.n24 17.0005
R419 vss.n107 vss.n24 17.0005
R420 vss.n105 vss.n24 17.0005
R421 vss.n103 vss.n24 17.0005
R422 vss.n101 vss.n24 17.0005
R423 vss.n99 vss.n24 17.0005
R424 vss.n97 vss.n24 17.0005
R425 vss.n95 vss.n24 17.0005
R426 vss.n93 vss.n24 17.0005
R427 vss.n91 vss.n24 17.0005
R428 vss.n89 vss.n24 17.0005
R429 vss.n87 vss.n24 17.0005
R430 vss.n174 vss.n24 17.0005
R431 vss.n173 vss.n24 17.0005
R432 vss.n177 vss.n24 17.0005
R433 vss.n176 vss.n24 17.0005
R434 vss.n180 vss.n24 17.0005
R435 vss.n179 vss.n24 17.0005
R436 vss.n183 vss.n24 17.0005
R437 vss.n182 vss.n24 17.0005
R438 vss.n186 vss.n24 17.0005
R439 vss.n185 vss.n24 17.0005
R440 vss.n189 vss.n24 17.0005
R441 vss.n188 vss.n24 17.0005
R442 vss.n192 vss.n24 17.0005
R443 vss.n191 vss.n24 17.0005
R444 vss.n195 vss.n24 17.0005
R445 vss.n194 vss.n24 17.0005
R446 vss.n198 vss.n24 17.0005
R447 vss.n197 vss.n24 17.0005
R448 vss.n201 vss.n24 17.0005
R449 vss.n200 vss.n24 17.0005
R450 vss.n204 vss.n24 17.0005
R451 vss.n203 vss.n24 17.0005
R452 vss.n207 vss.n24 17.0005
R453 vss.n206 vss.n24 17.0005
R454 vss.n210 vss.n24 17.0005
R455 vss.n209 vss.n24 17.0005
R456 vss.n213 vss.n24 17.0005
R457 vss.n212 vss.n24 17.0005
R458 vss.n216 vss.n24 17.0005
R459 vss.n215 vss.n24 17.0005
R460 vss.n219 vss.n24 17.0005
R461 vss.n218 vss.n24 17.0005
R462 vss.n222 vss.n24 17.0005
R463 vss.n221 vss.n24 17.0005
R464 vss.n225 vss.n24 17.0005
R465 vss.n224 vss.n24 17.0005
R466 vss.n228 vss.n24 17.0005
R467 vss.n227 vss.n24 17.0005
R468 vss.n231 vss.n24 17.0005
R469 vss.n230 vss.n24 17.0005
R470 vss.n234 vss.n24 17.0005
R471 vss.n233 vss.n24 17.0005
R472 vss.n237 vss.n24 17.0005
R473 vss.n236 vss.n24 17.0005
R474 vss.n240 vss.n24 17.0005
R475 vss.n239 vss.n24 17.0005
R476 vss.n366 vss.n24 17.0005
R477 vss.n365 vss.n24 17.0005
R478 vss.n363 vss.n24 17.0005
R479 vss.n361 vss.n24 17.0005
R480 vss.n359 vss.n24 17.0005
R481 vss.n243 vss.n24 17.0005
R482 vss.n355 vss.n24 17.0005
R483 vss.n100 vss.n19 8.49867
R484 vss.n160 vss.n19 17.0005
R485 vss.n88 vss.n20 8.49977
R486 vss.n90 vss.n20 8.49877
R487 vss.n92 vss.n20 8.49852
R488 vss.n94 vss.n20 8.49827
R489 vss.n96 vss.n20 8.49802
R490 vss.n98 vss.n20 8.49777
R491 vss.n102 vss.n20 8.49752
R492 vss.n104 vss.n20 8.49727
R493 vss.n106 vss.n20 8.49703
R494 vss.n108 vss.n20 8.49678
R495 vss.n110 vss.n20 8.49653
R496 vss.n112 vss.n20 8.49628
R497 vss.n114 vss.n20 8.49603
R498 vss.n116 vss.n20 8.49579
R499 vss.n118 vss.n20 8.49554
R500 vss.n120 vss.n20 8.4953
R501 vss.n122 vss.n20 8.49505
R502 vss.n124 vss.n20 8.4948
R503 vss.n126 vss.n20 8.49456
R504 vss.n128 vss.n20 8.49432
R505 vss.n130 vss.n20 8.49407
R506 vss.n132 vss.n20 8.49383
R507 vss.n134 vss.n20 8.49358
R508 vss.n136 vss.n20 8.49334
R509 vss.n138 vss.n20 8.4931
R510 vss.n140 vss.n20 8.49834
R511 vss.n142 vss.n20 8.49286
R512 vss.n144 vss.n20 8.49261
R513 vss.n146 vss.n20 8.49842
R514 vss.n148 vss.n20 8.49237
R515 vss.n150 vss.n20 8.49213
R516 vss.n152 vss.n20 8.49189
R517 vss.n154 vss.n20 8.49165
R518 vss.n156 vss.n20 8.49141
R519 vss.n158 vss.n20 8.49117
R520 vss.n29 vss.n20 3.79683
R521 vss.n63 vss.n172 17.0005
R522 vss.n15 vss.n14 0.685715
R523 vss.n13 vss.t83 17.0005
R524 vss.t81 vss.t39 17.0005
R525 vss.t90 vss.t88 17.0005
R526 vss.n171 vss.t38 17.0005
R527 vss.t21 vss.n50 4.24098
R528 vss.n8 vss.t77 0.0387224
R529 vss.t80 vss.n47 4.23949
R530 vss.t79 vss.t80 17.0005
R531 vss.t95 vss.n16 0.0383911
R532 vss.n17 vss.t98 0.0383911
R533 vss.t76 vss.t74 17.0005
R534 vss.n61 vss.t14 17.0005
R535 vss.t73 vss.t70 17.0005
R536 vss.n384 vss.t72 17.0005
R537 vss.n342 vss.t49 16.6364
R538 vss.n273 vss.t78 16.6364
R539 vss.n55 vss.t33 16.074
R540 vss.n359 vss.n358 15.7416
R541 vss.t64 vss.n32 14.8603
R542 vss.n247 vss.n55 14.8207
R543 vss.t17 vss.n362 14.4299
R544 vss.n314 vss.n313 13.8637
R545 vss.n312 vss.n311 13.8637
R546 vss.n310 vss.n309 13.8637
R547 vss.n308 vss.n307 13.8637
R548 vss.n306 vss.n305 13.8637
R549 vss.n304 vss.n303 13.8637
R550 vss.n302 vss.n301 13.8637
R551 vss.n300 vss.n299 13.8637
R552 vss.n298 vss.n297 13.8637
R553 vss.n296 vss.n295 13.8637
R554 vss.n294 vss.n293 13.8637
R555 vss.n292 vss.n291 13.8637
R556 vss.n290 vss.n289 13.8637
R557 vss.n288 vss.n287 13.8637
R558 vss.n286 vss.n285 13.8637
R559 vss.n284 vss.n283 13.8637
R560 vss.n282 vss.n281 13.8637
R561 vss.n280 vss.n279 13.8637
R562 vss.n278 vss.n277 13.8637
R563 vss.n276 vss.n275 13.8637
R564 vss.n274 vss.n273 13.8637
R565 vss.n272 vss.n271 13.8637
R566 vss.n270 vss.n269 13.8637
R567 vss.n268 vss.n267 13.8637
R568 vss.n266 vss.n265 13.8637
R569 vss.n264 vss.n263 13.8637
R570 vss.n262 vss.n261 13.8637
R571 vss.n260 vss.n259 13.8637
R572 vss.n258 vss.n257 13.8637
R573 vss.n256 vss.n255 13.8637
R574 vss.n254 vss.n253 13.8637
R575 vss.n252 vss.n251 13.8637
R576 vss.t67 vss.n38 13.188
R577 vss.t48 vss.n35 13.188
R578 vss.t43 vss.n239 13.1181
R579 vss.n250 vss.t86 12.4774
R580 vss.t101 vss.n143 11.8064
R581 vss.n373 vss.n372 11.4754
R582 vss.n123 vss.n122 10.4946
R583 vss.n121 vss.n120 10.4946
R584 vss.n119 vss.n118 10.4946
R585 vss.n117 vss.n116 10.4946
R586 vss.n115 vss.n114 10.4946
R587 vss.n113 vss.n112 10.4946
R588 vss.n111 vss.n110 10.4946
R589 vss.n109 vss.n108 10.4946
R590 vss.n107 vss.n106 10.4946
R591 vss.n105 vss.n104 10.4946
R592 vss.n103 vss.n102 10.4946
R593 vss.n101 vss.n100 10.4946
R594 vss.n99 vss.n98 10.4946
R595 vss.n97 vss.n96 10.4946
R596 vss.n93 vss.n92 10.4946
R597 vss.n91 vss.n90 10.4946
R598 vss.n89 vss.n88 10.4946
R599 vss.n161 vss.n87 10.4946
R600 vss.n161 vss.n19 1.06213
R601 vss.n63 vss.n367 8.5005
R602 vss.n63 vss.n64 8.5005
R603 vss.n63 vss.n241 8.5005
R604 vss.n63 vss.n65 8.5005
R605 vss.n63 vss.n238 8.5005
R606 vss.n63 vss.n66 8.5005
R607 vss.n63 vss.n235 8.5005
R608 vss.n63 vss.n67 8.5005
R609 vss.n63 vss.n232 8.5005
R610 vss.n63 vss.n242 8.5005
R611 vss.n63 vss.n360 8.5005
R612 vss.n63 vss.n362 8.5005
R613 vss.n63 vss.n364 8.5005
R614 vss.n63 vss.n244 8.5005
R615 vss.t53 vss.n357 8.5005
R616 vss.t53 vss.n251 8.5005
R617 vss.t53 vss.n253 8.5005
R618 vss.t53 vss.n255 8.5005
R619 vss.t53 vss.n257 8.5005
R620 vss.t53 vss.n259 8.5005
R621 vss.t53 vss.n261 8.5005
R622 vss.t53 vss.n263 8.5005
R623 vss.t53 vss.n265 8.5005
R624 vss.t53 vss.n267 8.5005
R625 vss.t53 vss.n269 8.5005
R626 vss.t53 vss.n271 8.5005
R627 vss.t53 vss.n273 8.5005
R628 vss.t53 vss.n275 8.5005
R629 vss.t53 vss.n277 8.5005
R630 vss.t53 vss.n279 8.5005
R631 vss.t53 vss.n281 8.5005
R632 vss.t53 vss.n283 8.5005
R633 vss.t53 vss.n285 8.5005
R634 vss.t53 vss.n287 8.5005
R635 vss.t53 vss.n289 8.5005
R636 vss.t53 vss.n291 8.5005
R637 vss.t53 vss.n293 8.5005
R638 vss.t53 vss.n295 8.5005
R639 vss.t53 vss.n297 8.5005
R640 vss.t53 vss.n299 8.5005
R641 vss.t53 vss.n301 8.5005
R642 vss.t53 vss.n303 8.5005
R643 vss.t53 vss.n305 8.5005
R644 vss.t53 vss.n307 8.5005
R645 vss.t53 vss.n309 8.5005
R646 vss.t53 vss.n311 8.5005
R647 vss.t53 vss.n313 8.5005
R648 vss.t53 vss.n315 8.5005
R649 vss.t53 vss.n317 8.5005
R650 vss.t53 vss.n319 8.5005
R651 vss.t53 vss.n321 8.5005
R652 vss.t53 vss.n323 8.5005
R653 vss.t53 vss.n325 8.5005
R654 vss.t53 vss.n327 8.5005
R655 vss.t53 vss.n329 8.5005
R656 vss.t53 vss.n331 8.5005
R657 vss.t53 vss.n333 8.5005
R658 vss.t53 vss.n335 8.5005
R659 vss.t53 vss.n337 8.5005
R660 vss.t53 vss.n339 8.5005
R661 vss.t53 vss.n341 8.5005
R662 vss.t53 vss.n343 8.5005
R663 vss.t53 vss.n345 8.5005
R664 vss.t53 vss.n347 8.5005
R665 vss.t53 vss.n349 8.5005
R666 vss.t53 vss.n351 8.5005
R667 vss.t53 vss.n353 8.5005
R668 vss.n63 vss.n68 8.5005
R669 vss.n63 vss.n229 8.5005
R670 vss.n63 vss.n69 8.5005
R671 vss.n63 vss.n226 8.5005
R672 vss.n63 vss.n70 8.5005
R673 vss.n63 vss.n223 8.5005
R674 vss.n63 vss.n71 8.5005
R675 vss.n63 vss.n220 8.5005
R676 vss.n63 vss.n72 8.5005
R677 vss.n63 vss.n217 8.5005
R678 vss.n63 vss.n73 8.5005
R679 vss.n63 vss.n214 8.5005
R680 vss.n63 vss.n74 8.5005
R681 vss.n63 vss.n211 8.5005
R682 vss.n63 vss.n75 8.5005
R683 vss.n63 vss.n208 8.5005
R684 vss.n63 vss.n76 8.5005
R685 vss.n63 vss.n205 8.5005
R686 vss.n63 vss.n77 8.5005
R687 vss.n63 vss.n202 8.5005
R688 vss.n63 vss.n78 8.5005
R689 vss.n63 vss.n199 8.5005
R690 vss.n63 vss.n79 8.5005
R691 vss.n63 vss.n196 8.5005
R692 vss.n63 vss.n80 8.5005
R693 vss.n63 vss.n193 8.5005
R694 vss.n63 vss.n81 8.5005
R695 vss.n63 vss.n190 8.5005
R696 vss.n63 vss.n82 8.5005
R697 vss.n63 vss.n187 8.5005
R698 vss.n63 vss.n83 8.5005
R699 vss.n63 vss.n184 8.5005
R700 vss.n63 vss.n84 8.5005
R701 vss.n63 vss.n181 8.5005
R702 vss.n63 vss.n85 8.5005
R703 vss.n63 vss.n178 8.5005
R704 vss.n63 vss.n86 8.5005
R705 vss.n63 vss.n175 8.5005
R706 vss.n63 vss.n166 8.5005
R707 vss.t21 vss.n8 5.65127
R708 vss.n368 vss.t7 8.49188
R709 vss.t97 vss.t95 8.49188
R710 vss.n16 vss.t23 5.65138
R711 vss.t98 vss.t32 8.49188
R712 vss.t100 vss.n17 5.65138
R713 vss.t77 vss.t7 8.49176
R714 vss.n10 vss.n9 0.0387794
R715 vss.n12 vss.n11 0.0387794
R716 vss.t9 vss.n369 8.49087
R717 vss.n370 vss.t80 8.49087
R718 vss.n60 vss.t76 8.49087
R719 vss.n59 vss.t14 8.49087
R720 vss.n383 vss.t73 8.49087
R721 vss.n382 vss.t72 8.49087
R722 vss.t9 vss.n371 8.49074
R723 vss.t44 vss.n246 8.48783
R724 vss.t51 vss.n245 8.48783
R725 vss.n0 vss.t47 8.48783
R726 vss.n3 vss.t50 5.61585
R727 vss.t56 vss.t53 5.47923
R728 vss.t87 vss.t53 5.47915
R729 vss.t83 vss.n168 8.48783
R730 vss.t39 vss.n167 8.48783
R731 vss.n170 vss.t90 8.48783
R732 vss.n169 vss.t38 8.48783
R733 vss.n200 vss.t40 7.87107
R734 vss.n95 vss.t3 6.55931
R735 vss.n208 vss.t13 6.55931
R736 vss.n10 vss.t97 3.39025
R737 vss.n12 vss.t32 3.39025
R738 vss.n50 vss.t7 5.6831
R739 vss.t9 vss.n47 5.68522
R740 vss.n316 vss.t52 5.54579
R741 vss.t75 vss.n194 5.24755
R742 vss.t34 vss.n48 4.4755
R743 vss.t25 vss.n9 4.4755
R744 vss.n56 vss.n11 4.4755
R745 vss.n52 vss.n62 4.4755
R746 vss.t103 vss.n385 4.4755
R747 vss.t14 vss.n58 4.25206
R748 vss.t72 vss.n381 4.25206
R749 vss.t76 vss.n58 4.25175
R750 vss.t73 vss.n381 4.25175
R751 vss.n12 vss.t100 4.26625
R752 vss.n57 vss.n51 4.1005
R753 vss.n154 vss.t2 3.93579
R754 vss.t3 vss.n94 3.93579
R755 vss.t15 vss.n69 3.93579
R756 vss.n222 vss.t42 2.62402
R757 vss.n125 vss.n24 2.34678
R758 vss.n164 vss.n24 2.34678
R759 vss.n165 vss.n24 2.34678
R760 vss.t103 vss.n6 2.27125
R761 vss.t16 vss.n4 2.26086
R762 vss.n53 vss.n24 2.14665
R763 vss.n374 vss.n24 2.14665
R764 vss.n372 vss.n40 1.36272
R765 vss.n40 vss.n55 1.36272
R766 vss.n21 vss.t103 4.80224
R767 vss.n22 vss.n23 1.12783
R768 vss.n56 vss.n24 1.7288
R769 vss.n2 vss.n4 0.278891
R770 vss.n15 vss.t41 0.00252425
R771 vss.n4 vss.t41 0.676742
R772 vss.n28 vss.n26 1.32089
R773 vss.n163 vss.n24 0.331038
R774 vss.n23 vss.n28 2.85186
R775 vss.t25 vss.t34 0.309901
R776 vss.n249 vss.n24 0.305009
R777 vss.n248 vss.n24 0.305009
R778 vss.n0 vss.n2 0.213636
R779 vss.n57 vss.t16 0.135543
R780 vss.n40 vss.n39 0.120581
R781 vss.n40 vss.n37 0.120581
R782 vss.n40 vss.n34 0.120581
R783 vss.n40 vss.n33 0.120581
R784 vss.n40 vss.n31 0.120581
R785 vss.n40 vss.n30 0.120581
R786 vss.n40 vss.n36 0.116916
R787 vss.n28 vss.n19 0.0534113
R788 vss.n0 vss.n1 0.0899444
R789 vss.n172 vss.n171 0.0899444
R790 vss.n14 vss.n13 0.0899444
R791 vss.n56 vss.t25 0.0835571
R792 vss.n22 vss.n21 0.861854
R793 vss.t16 vss.n52 0.0654286
R794 vss.n48 vss.n47 0.0491388
R795 vss.n51 vss.n50 0.0444465
R796 vss.n246 vss.n245 0.054196
R797 vss.n170 vss.n169 0.054196
R798 vss.n168 vss.n167 0.054196
R799 vss.t34 vss.n57 0.0533429
R800 vss.n162 vss.n24 0.0475125
R801 vss.n46 vss.n24 0.0396081
R802 vss.n371 vss.n370 0.0422843
R803 vss.n370 vss.n369 0.0420072
R804 vss.n60 vss.n59 0.0420072
R805 vss.n383 vss.n382 0.0420072
R806 vss.n62 vss.n61 0.0410556
R807 vss.n385 vss.n384 0.0410556
R808 vss.n15 vss.n63 0.0372389
R809 vss.n62 vss.n58 0.0382434
R810 vss.n385 vss.n381 0.0382434
R811 vss.n16 vss.n9 0.0573869
R812 vss.n8 vss.n368 0.0573029
R813 vss.n40 vss.n38 0.0365679
R814 vss.n40 vss.n35 0.0365679
R815 vss.n40 vss.n32 0.0365679
R816 vss.n44 vss.n247 36.2015
R817 vss.n52 vss.t103 0.240329
R818 vss.n22 vss.n27 0.0835544
R819 vss.n24 vss.n40 0.064347
R820 vss.n6 vss.n5 0.0624705
R821 vss.n17 vss.n11 0.0573869
R822 vss.n20 vss.n19 0.0408058
R823 vss.n375 vss.n24 0.0363214
R824 vss.n376 vss.n24 0.0363214
R825 vss.n377 vss.n24 0.0363214
R826 vss.n378 vss.n24 0.0363214
R827 vss.n379 vss.n24 0.0363214
R828 vss.n380 vss.n24 0.0363214
R829 vss.n43 vss.n42 0.0396093
R830 vss.n246 vss.t84 0.027348
R831 vss.t91 vss.n3 0.0970889
R832 vss.n1 vss.n245 0.027348
R833 vss.n168 vss.t81 0.027348
R834 vss.n171 vss.n170 0.027348
R835 vss.t88 vss.n169 0.027348
R836 vss.n13 vss.n167 0.027348
R837 vss.n369 vss.n48 0.0218092
R838 vss.n371 vss.t79 0.0215307
R839 vss.n61 vss.n60 0.0212536
R840 vss.t74 vss.n59 0.0212536
R841 vss.n384 vss.n383 0.0212536
R842 vss.t70 vss.n382 0.0212536
R843 vss.n368 vss.n51 0.0197304
R844 vss.n26 vss.n43 0.0388845
R845 vss.n172 vss.n14 0.0382778
R846 vss.n10 vss.t23 4.26625
R847 vss.t53 vss.n0 1.38163
R848 vss vss.n0 0.0005
C174 out vss 67.4847f
C175 inn vss 3.90159f
C176 inp vss 4.27882f
C177 ibias vss 12.9531f
C178 a_9508_346# vss 0.38118f ; **FLOATING
C179 a_14767_2795# vss 13.19872f ; **FLOATING
C180 a_12881_2795# vss 1.69786f ; **FLOATING
C181 a_14767_3159# vss 1.63674f ; **FLOATING
C182 a_12881_3523# vss 1.6197f ; **FLOATING
C183 a_12881_4251# vss 1.62754f ; **FLOATING
C184 a_14767_4615# vss 1.64562f ; **FLOATING
C185 a_14767_5343# vss 14.34004f ; **FLOATING
C186 a_12881_4979# vss 1.7587f ; **FLOATING
C187 a_3520_5051# vss 1.27229f ; **FLOATING
C188 a_592_2733# vss 1.52525f ; **FLOATING
C189 a_8488_4945# vss 11.0007f ; **FLOATING
C190 a_4818_4945# vss 11.9279f ; **FLOATING
C191 a_1076_5541# vss 4.9529f ; **FLOATING
C192 a_6733_6167# vss 1.97732f ; **FLOATING
C193 a_442_5111# vss 4.54669f ; **FLOATING
C194 a_592_286# vss 6.98885f ; **FLOATING
C195 a_1392_382# vss 3.46901f ; **FLOATING
C196 a_5933_6071# vss 12.1437f ; **FLOATING
C197 a_9288_5041# vss 11.75108f ; **FLOATING
C198 a_11355_6131# vss 1.64332f ; **FLOATING
C199 vss.t25 vss 2.07146f ; **FLOATING
C200 vss.t34 vss 2.10688f ; **FLOATING
C201 out.t1 vss 77.4888f ; **FLOATING
C202 out.t0 vss 0.56062p ; **FLOATING
.ends
