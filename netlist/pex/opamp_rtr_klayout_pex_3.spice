* NGSPICE file created from opamp_rtr_pex.ext - technology: ihp-sg13cmos5l

.subckt opamp_rtr_pex vdd inp vss inn ibias out
X0 out.t0 a_9288_5041# vss.t25 vss.t30 sg13_hv_nmos ad=0.475p pd=2.88u as=0.475p ps=2.88u w=2.5u l=1u
X1 vdd a_592_286# a_1392_382# vdd sg13_hv_pmos ad=1.425p pd=7.88u as=1.425p ps=7.88u w=7.5u l=4u
X2 w_8388_2366# w_8388_2366# w_8388_2366# w_8388_2366# sg13_hv_pmos ad=0.7125p pd=4.13u as=62.7835p ps=0.25869m w=3.75u l=0.4u
X3 vss.t76 ibias a_442_5111# vss.t108 sg13_hv_nmos ad=0.475p pd=2.88u as=0.475p ps=2.88u w=2.5u l=4u
X4 a_442_5111# a_442_5111# a_442_5111# vss.t3 sg13_hv_nmos ad=0.2375p pd=1.63u as=13.7666p ps=96.82u w=1.25u l=0.45u
X5 out a_1076_5541# vdd vdd sg13_hv_pmos ad=1.425p pd=7.88u as=1.425p ps=7.88u w=7.5u l=1u
X6 vss.t98 vss.t96 vss.t23 vss.t97 sg13_hv_nmos ad=0.85p pd=5.68u as=0 ps=0 w=2.5u l=0.45u
X7 ibias ibias vss.t104 vss.t106 sg13_hv_nmos ad=0.475p pd=2.88u as=0.475p ps=2.88u w=2.5u l=4u
X8 vdd vdd vdd vdd sg13_hv_pmos ad=0.7125p pd=4.13u as=0.18065n ps=0.47106m w=3.75u l=0.4u
X9 w_8388_2366# a_592_286# vdd vdd sg13_hv_pmos ad=1.425p pd=7.88u as=1.425p ps=7.88u w=7.5u l=4u
X10 a_9288_5041# inp w_8388_2366# w_8388_2366# sg13_hv_pmos ad=0.7125p pd=4.13u as=0.7125p ps=4.13u w=3.75u l=2u
X11 a_9288_5041# a_8488_4945# vss.t50 vss.t49 sg13_hv_nmos ad=0.2375p pd=1.63u as=0.2375p ps=1.63u w=1.25u l=4u
X12 a_592_2733# a_592_2733# vdd vdd sg13_hv_pmos ad=0.7125p pd=4.13u as=0.7125p ps=4.13u w=3.75u l=4u
X13 a_442_5111# a_442_5111# a_442_5111# vss.t5 sg13_hv_nmos ad=0.475p pd=2.88u as=0 ps=0 w=2.5u l=0.45u
X14 w_8388_2366# inn a_8488_4945# w_8388_2366# sg13_hv_pmos ad=0.7125p pd=4.13u as=0.7125p ps=4.13u w=3.75u l=2u
X15 w_8388_2366# a_3520_5051# vdd vdd sg13_hv_pmos ad=0.7125p pd=4.13u as=0.7125p ps=4.13u w=3.75u l=4u
X16 out.t1 a_9288_5041# vss.t25 vss.t26 sg13_hv_nmos ad=0.475p pd=2.88u as=0.475p ps=2.88u w=2.5u l=1u
X17 a_592_2733# inn a_442_5111# vss.t62 sg13_hv_nmos ad=0.2375p pd=1.63u as=0.2375p ps=1.63u w=1.25u l=2u
X18 a_12881_4979# a_14767_4615# vss.t64 rhigh l=9u w=1u
X19 w_8388_2366# w_8388_2366# w_8388_2366# w_8388_2366# sg13_hv_pmos ad=2.55p pd=15.68u as=0 ps=0 w=7.5u l=0.4u
X20 a_11355_6131# a_1392_382# a_1392_382# vss.t11 sg13_hv_nmos ad=0.475p pd=2.88u as=0.475p ps=2.88u w=2.5u l=1u
X21 a_442_5111# a_4818_4945# vss.t41 vss.t42 sg13_hv_nmos ad=0.2375p pd=1.63u as=0.2375p ps=1.63u w=1.25u l=4u
X22 a_8488_4945# inn w_8388_2366# w_8388_2366# sg13_hv_pmos ad=0.7125p pd=4.13u as=0.7125p ps=4.13u w=3.75u l=2u
X23 vss.t83 vss.t81 vss.t39 vss.t82 sg13_hv_nmos ad=0.425p pd=3.18u as=0 ps=0 w=1.25u l=0.45u
X24 vss.t34 vss.t34 vss.t33 rhigh l=9u w=1u
X25 a_1076_5541# a_592_2733# vdd vdd sg13_hv_pmos ad=0.7125p pd=4.13u as=0.7125p ps=4.13u w=3.75u l=4u
X26 vss.t21 vss.t77 vss.t7 vss.t78 sg13_hv_nmos ad=0.475p pd=2.88u as=0 ps=0 w=2.5u l=0.45u
X27 a_12881_4251# a_1076_5541# vss.t35 rhigh l=9u w=1u
X28 vdd vdd vdd vdd sg13_hv_pmos ad=1.275p pd=8.18u as=0 ps=0 w=3.75u l=0.4u
X29 a_9288_5041# a_8488_4945# vss.t53 vss.t54 sg13_hv_nmos ad=0.2375p pd=1.63u as=0.2375p ps=1.63u w=1.25u l=4u
X30 a_442_5111# a_592_286# a_3520_5051# vss.t1 sg13_hv_nmos ad=0.475p pd=2.88u as=0.475p ps=2.88u w=2.5u l=1u
X31 vss.t25 a_9288_5041# out.t1 vss.t24 sg13_hv_nmos ad=0.475p pd=2.88u as=0.475p ps=2.88u w=2.5u l=1u
X32 a_1076_5541# a_1076_5541# a_1076_5541# vdd sg13_hv_pmos ad=1.425p pd=7.88u as=34.7735p ps=0.10686m w=7.5u l=1u
X33 vdd a_592_286# a_5933_6071# vdd sg13_hv_pmos ad=1.425p pd=7.88u as=1.425p ps=7.88u w=7.5u l=4u
X34 a_12881_2795# a_14767_3159# vss.t69 rhigh l=9u w=1u
X35 a_442_5111# inn a_592_2733# vss.t61 sg13_hv_nmos ad=0.2375p pd=1.63u as=0.2375p ps=1.63u w=1.25u l=2u
X36 vdd a_1076_5541# out vdd sg13_hv_pmos ad=1.425p pd=7.88u as=1.425p ps=7.88u w=7.5u l=1u
X37 vss.t25 vss.t25 vss.t66 rhigh l=9u w=1u
X38 vss.t9 vss.t79 vss.t80 vss.t12 sg13_hv_nmos ad=0.475p pd=2.88u as=0 ps=0 w=2.5u l=0.45u
X39 vss.t104 ibias a_592_286# vss.t103 sg13_hv_nmos ad=0.475p pd=2.88u as=0.475p ps=2.88u w=2.5u l=4u
X40 vdd vdd vdd vdd sg13_hv_pmos ad=0.7125p pd=4.13u as=0 ps=0 w=3.75u l=0.4u
X41 vss.t16 a_5933_6071# a_5933_6071# vss.t18 sg13_hv_nmos ad=0.475p pd=2.88u as=0.475p ps=2.88u w=2.5u l=4u
X42 vdd a_592_2733# a_1076_5541# vdd sg13_hv_pmos ad=0.7125p pd=4.13u as=0.7125p ps=4.13u w=3.75u l=4u
X43 a_3520_5051# a_592_286# a_442_5111# vss.t0 sg13_hv_nmos ad=0.475p pd=2.88u as=0.475p ps=2.88u w=2.5u l=1u
X44 vdd a_592_2733# a_1076_5541# vdd sg13_hv_pmos ad=0.7125p pd=4.13u as=0.7125p ps=4.13u w=3.75u l=4u
X45 a_9508_346# a_9508_346# vdd vdd sg13_hv_pmos ad=1.425p pd=7.88u as=1.425p ps=7.88u w=7.5u l=1u
X46 vdd a_3520_5051# a_3520_5051# vdd sg13_hv_pmos ad=0.7125p pd=4.13u as=0.7125p ps=4.13u w=3.75u l=4u
X47 a_4818_4945# a_4818_4945# vss.t39 vss.t37 sg13_hv_nmos ad=0.2375p pd=1.63u as=0.2375p ps=1.63u w=1.25u l=4u
X48 a_442_5111# inp a_1076_5541# vss.t63 sg13_hv_nmos ad=0.2375p pd=1.63u as=0.2375p ps=1.63u w=1.25u l=2u
X49 vdd a_3520_5051# a_3520_5051# vdd sg13_hv_pmos ad=0.7125p pd=4.13u as=0.7125p ps=4.13u w=3.75u l=4u
X50 vdd vdd vdd vdd sg13_hv_pmos ad=2.55p pd=15.68u as=0 ps=0 w=7.5u l=0.4u
X51 vss.t41 a_4818_4945# a_4818_4945# vss.t40 sg13_hv_nmos ad=0.2375p pd=1.63u as=0.2375p ps=1.63u w=1.25u l=4u
X52 a_442_5111# ibias vss.t104 vss.t105 sg13_hv_nmos ad=0.475p pd=2.88u as=0.475p ps=2.88u w=2.5u l=4u
X53 w_8388_2366# a_3520_5051# vdd vdd sg13_hv_pmos ad=0.7125p pd=4.13u as=0.7125p ps=4.13u w=3.75u l=4u
X54 a_5933_6071# a_592_286# vdd vdd sg13_hv_pmos ad=1.425p pd=7.88u as=1.425p ps=7.88u w=7.5u l=4u
X55 a_1076_5541# a_592_286# vdd vdd sg13_hv_pmos ad=1.425p pd=7.88u as=1.425p ps=7.88u w=7.5u l=4u
X56 a_4818_4945# a_4818_4945# vss.t41 vss.t42 sg13_hv_nmos ad=0.2375p pd=1.63u as=0.2375p ps=1.63u w=1.25u l=4u
X57 a_442_5111# inp a_1076_5541# vss.t61 sg13_hv_nmos ad=0.2375p pd=1.63u as=0.2375p ps=1.63u w=1.25u l=2u
X58 vss.t91 vss.t89 vss.t38 vss.t82 sg13_hv_nmos ad=0.425p pd=3.18u as=0 ps=0 w=1.25u l=0.45u
X59 w_8388_2366# w_8388_2366# w_8388_2366# w_8388_2366# sg13_hv_pmos ad=0.7125p pd=4.13u as=0 ps=0 w=3.75u l=0.4u
X60 vss.t21 a_5933_6071# a_9288_5041# vss.t20 sg13_hv_nmos ad=0.475p pd=2.88u as=0.475p ps=2.88u w=2.5u l=4u
X61 vss.t56 vss.t86 vss.t88 vss.t87 sg13_hv_nmos ad=0.2375p pd=1.63u as=0 ps=0 w=1.25u l=0.45u
X62 vdd a_1076_5541# out vdd sg13_hv_pmos ad=1.425p pd=7.88u as=1.425p ps=7.88u w=7.5u l=1u
X63 vss.t44 vss.t84 vss.t51 vss.t85 sg13_hv_nmos ad=0.2375p pd=1.63u as=0 ps=0 w=1.25u l=0.45u
X64 a_9288_5041# a_9288_5041# a_9288_5041# vss.t12 sg13_hv_nmos ad=0.85p pd=5.68u as=17.3283p ps=85.93999u w=2.5u l=1u
X65 vdd vdd vdd vdd sg13_hv_pmos ad=1.425p pd=7.88u as=0 ps=0 w=7.5u l=0.4u
X66 a_9288_5041# a_9288_5041# a_9288_5041# vss.t12 sg13_hv_nmos ad=0.475p pd=2.88u as=0 ps=0 w=2.5u l=1u
X67 a_8488_4945# inn w_8388_2366# w_8388_2366# sg13_hv_pmos ad=0.7125p pd=4.13u as=0.7125p ps=4.13u w=3.75u l=2u
X68 a_8488_4945# a_8488_4945# vss.t53 vss.t54 sg13_hv_nmos ad=0.2375p pd=1.63u as=0.2375p ps=1.63u w=1.25u l=4u
X69 w_8388_2366# w_8388_2366# w_8388_2366# w_8388_2366# sg13_hv_pmos ad=1.275p pd=8.18u as=0 ps=0 w=3.75u l=0.4u
X70 vss.t73 vss.t70 vss.t72 vss.t71 sg13_hv_nmos ad=0.85p pd=5.68u as=0 ps=0 w=2.5u l=0.45u
X71 a_12881_3523# a_9288_5041# vss.t48 rhigh l=9u w=1u
X72 vdd a_592_286# a_1076_5541# vdd sg13_hv_pmos ad=1.425p pd=7.88u as=1.425p ps=7.88u w=7.5u l=4u
X73 a_592_2733# inn a_442_5111# vss.t60 sg13_hv_nmos ad=0.2375p pd=1.63u as=0.2375p ps=1.63u w=1.25u l=2u
X74 a_442_5111# inn a_592_2733# vss.t63 sg13_hv_nmos ad=0.2375p pd=1.63u as=0.2375p ps=1.63u w=1.25u l=2u
X75 a_1392_382# a_1392_382# a_11355_6131# vss.t10 sg13_hv_nmos ad=0.475p pd=2.88u as=0.475p ps=2.88u w=2.5u l=1u
X76 a_9288_5041# inp w_8388_2366# w_8388_2366# sg13_hv_pmos ad=0.7125p pd=4.13u as=0.7125p ps=4.13u w=3.75u l=2u
X77 vss.t16 a_5933_6071# a_6733_6167# vss.t15 sg13_hv_nmos ad=0.475p pd=2.88u as=0.475p ps=2.88u w=2.5u l=4u
X78 out.t1 a_9288_5041# vss.t23 vss.t22 sg13_hv_nmos ad=0.475p pd=2.88u as=0.475p ps=2.88u w=2.5u l=1u
X79 a_1076_5541# a_6733_6167# a_9288_5041# vdd sg13_hv_pmos ad=1.425p pd=7.88u as=1.425p ps=7.88u w=7.5u l=1u
X80 vdd a_9508_346# a_9508_346# vdd sg13_hv_pmos ad=1.425p pd=7.88u as=1.425p ps=7.88u w=7.5u l=1u
X81 a_12881_4251# a_14767_4615# vss.t65 rhigh l=9u w=1u
X82 a_5933_6071# a_5933_6071# vss.t16 vss.t17 sg13_hv_nmos ad=0.475p pd=2.88u as=0.475p ps=2.88u w=2.5u l=4u
X83 a_442_5111# a_442_5111# a_442_5111# vss.t2 sg13_hv_nmos ad=0.425p pd=3.18u as=0 ps=0 w=1.25u l=0.45u
X84 a_1076_5541# a_592_2733# vdd vdd sg13_hv_pmos ad=0.7125p pd=4.13u as=0.7125p ps=4.13u w=3.75u l=4u
X85 vss.t76 vss.t74 vss.t14 vss.t75 sg13_hv_nmos ad=0.475p pd=2.88u as=0 ps=0 w=2.5u l=0.45u
X86 vdd vdd vdd vdd sg13_hv_pmos ad=1.425p pd=7.88u as=0 ps=0 w=7.5u l=0.4u
X87 a_442_5111# a_4818_4945# vss.t38 vss.t37 sg13_hv_nmos ad=0.2375p pd=1.63u as=0.2375p ps=1.63u w=1.25u l=4u
X88 a_9508_346# a_6733_6167# a_6733_6167# vdd sg13_hv_pmos ad=1.425p pd=7.88u as=1.425p ps=7.88u w=7.5u l=1u
X89 vss.t104 ibias ibias vss.t107 sg13_hv_nmos ad=0.475p pd=2.88u as=0.475p ps=2.88u w=2.5u l=4u
X90 vss.t25 a_9288_5041# out.t1 vss.t29 sg13_hv_nmos ad=0.475p pd=2.88u as=0.475p ps=2.88u w=2.5u l=1u
X91 out a_1076_5541# vdd vdd sg13_hv_pmos ad=1.425p pd=7.88u as=1.425p ps=7.88u w=7.5u l=1u
X92 vss.t41 a_4818_4945# a_442_5111# vss.t40 sg13_hv_nmos ad=0.2375p pd=1.63u as=0.2375p ps=1.63u w=1.25u l=4u
X93 a_4818_4945# a_592_286# w_8388_2366# w_8388_2366# sg13_hv_pmos ad=1.425p pd=7.88u as=1.425p ps=7.88u w=7.5u l=1u
X94 a_11355_6131# a_11355_6131# vss.t7 vss.t6 sg13_hv_nmos ad=0.475p pd=2.88u as=0.475p ps=2.88u w=2.5u l=1u
X95 a_592_2733# a_592_2733# vdd vdd sg13_hv_pmos ad=0.7125p pd=4.13u as=0.7125p ps=4.13u w=3.75u l=4u
X96 vss.t9 a_11355_6131# a_11355_6131# vss.t8 sg13_hv_nmos ad=0.475p pd=2.88u as=0.475p ps=2.88u w=2.5u l=1u
X97 vss.t53 a_8488_4945# a_8488_4945# vss.t52 sg13_hv_nmos ad=0.2375p pd=1.63u as=0.2375p ps=1.63u w=1.25u l=4u
X98 a_9288_5041# a_6733_6167# a_1076_5541# vdd sg13_hv_pmos ad=1.425p pd=7.88u as=1.425p ps=7.88u w=7.5u l=1u
X99 vdd vdd vdd vdd sg13_hv_pmos ad=0.7125p pd=4.13u as=0 ps=0 w=3.75u l=0.4u
X100 vdd vdd vdd vdd sg13_hv_pmos ad=1.275p pd=8.18u as=0 ps=0 w=3.75u l=0.4u
X101 w_8388_2366# inn a_8488_4945# w_8388_2366# sg13_hv_pmos ad=0.7125p pd=4.13u as=0.7125p ps=4.13u w=3.75u l=2u
X102 vss.t44 a_4818_4945# a_442_5111# vss.t43 sg13_hv_nmos ad=0.2375p pd=1.63u as=0.2375p ps=1.63u w=1.25u l=4u
X103 a_1076_5541# inp a_442_5111# vss.t60 sg13_hv_nmos ad=0.2375p pd=1.63u as=0.2375p ps=1.63u w=1.25u l=2u
X104 vss.t59 vss.t94 vss.t95 vss.t87 sg13_hv_nmos ad=0.2375p pd=1.63u as=0 ps=0 w=1.25u l=0.45u
X105 a_1076_5541# a_1392_382# a_9288_5041# vss.t12 sg13_hv_nmos ad=0.475p pd=2.88u as=0.475p ps=2.88u w=2.5u l=1u
X106 a_3520_5051# a_3520_5051# vdd vdd sg13_hv_pmos ad=0.7125p pd=4.13u as=0.7125p ps=4.13u w=3.75u l=4u
X107 vss.t47 vss.t92 vss.t50 vss.t85 sg13_hv_nmos ad=0.2375p pd=1.63u as=0 ps=0 w=1.25u l=0.45u
X108 a_442_5111# a_442_5111# a_442_5111# vss.t2 sg13_hv_nmos ad=0.425p pd=3.18u as=0 ps=0 w=1.25u l=0.45u
X109 out.t1 a_9288_5041# vss.t25 vss.t28 sg13_hv_nmos ad=0.475p pd=2.88u as=0.475p ps=2.88u w=2.5u l=1u
X110 vdd a_592_286# w_8388_2366# vdd sg13_hv_pmos ad=1.425p pd=7.88u as=1.425p ps=7.88u w=7.5u l=4u
X111 vss.t56 a_8488_4945# a_9288_5041# vss.t55 sg13_hv_nmos ad=0.2375p pd=1.63u as=0.2375p ps=1.63u w=1.25u l=4u
X112 w_8388_2366# w_8388_2366# w_8388_2366# w_8388_2366# sg13_hv_pmos ad=1.425p pd=7.88u as=0 ps=0 w=7.5u l=0.4u
X113 vdd a_592_286# a_592_286# vdd sg13_hv_pmos ad=1.425p pd=7.88u as=1.425p ps=7.88u w=7.5u l=4u
X114 w_8388_2366# inp a_9288_5041# w_8388_2366# sg13_hv_pmos ad=0.7125p pd=4.13u as=0.7125p ps=4.13u w=3.75u l=2u
X115 vss.t25 a_9288_5041# out.t1 vss.t27 sg13_hv_nmos ad=0.475p pd=2.88u as=0.475p ps=2.88u w=2.5u l=1u
X116 vdd a_592_2733# a_592_2733# vdd sg13_hv_pmos ad=0.7125p pd=4.13u as=0.7125p ps=4.13u w=3.75u l=4u
X117 out a_1076_5541# vdd vdd sg13_hv_pmos ad=1.425p pd=7.88u as=1.425p ps=7.88u w=7.5u l=1u
X118 vdd a_3520_5051# w_8388_2366# vdd sg13_hv_pmos ad=0.7125p pd=4.13u as=0.7125p ps=4.13u w=3.75u l=4u
X119 a_9288_5041# a_1392_382# a_1076_5541# vss.t12 sg13_hv_nmos ad=0.475p pd=2.88u as=0.475p ps=2.88u w=2.5u l=1u
X120 a_1392_382# a_592_286# vdd vdd sg13_hv_pmos ad=1.425p pd=7.88u as=1.425p ps=7.88u w=7.5u l=4u
X121 w_8388_2366# w_8388_2366# w_8388_2366# w_8388_2366# sg13_hv_pmos ad=1.275p pd=8.18u as=0 ps=0 w=3.75u l=0.4u
X122 a_3520_5051# a_3520_5051# vdd vdd sg13_hv_pmos ad=0.7125p pd=4.13u as=0.7125p ps=4.13u w=3.75u l=4u
X123 a_12881_4979# a_14767_5343# vss.t36 rhigh l=9u w=1u
X124 a_9288_5041# a_5933_6071# vss.t16 vss.t19 sg13_hv_nmos ad=0.475p pd=2.88u as=0.475p ps=2.88u w=2.5u l=4u
X125 vdd a_1076_5541# out vdd sg13_hv_pmos ad=1.425p pd=7.88u as=1.425p ps=7.88u w=7.5u l=1u
X126 vss.t32 vss.t99 vss.t101 vss.t100 sg13_hv_nmos ad=0.475p pd=2.88u as=0 ps=0 w=2.5u l=0.45u
X127 a_12881_2795# a_14767_2795# vss.t67 rhigh l=9u w=1u
X128 w_8388_2366# a_592_286# a_4818_4945# w_8388_2366# sg13_hv_pmos ad=1.425p pd=7.88u as=1.425p ps=7.88u w=7.5u l=1u
X129 a_8488_4945# a_8488_4945# vss.t51 vss.t49 sg13_hv_nmos ad=0.2375p pd=1.63u as=0.2375p ps=1.63u w=1.25u l=4u
X130 vdd vdd vdd vdd sg13_hv_pmos ad=0.7125p pd=4.13u as=0 ps=0 w=3.75u l=0.4u
X131 vdd a_592_2733# a_592_2733# vdd sg13_hv_pmos ad=0.7125p pd=4.13u as=0.7125p ps=4.13u w=3.75u l=4u
X132 vss.t53 a_8488_4945# a_9288_5041# vss.t52 sg13_hv_nmos ad=0.2375p pd=1.63u as=0.2375p ps=1.63u w=1.25u l=4u
X133 a_12881_3523# a_14767_3159# vss.t68 rhigh l=9u w=1u
X134 vdd a_3520_5051# w_8388_2366# vdd sg13_hv_pmos ad=0.7125p pd=4.13u as=0.7125p ps=4.13u w=3.75u l=4u
X135 a_442_5111# a_442_5111# a_442_5111# vss.t4 sg13_hv_nmos ad=0.85p pd=5.68u as=0 ps=0 w=2.5u l=0.45u
X136 vdd vdd vdd vdd sg13_hv_pmos ad=2.55p pd=15.68u as=0 ps=0 w=7.5u l=0.4u
X137 a_592_286# a_592_286# vdd vdd sg13_hv_pmos ad=1.425p pd=7.88u as=1.425p ps=7.88u w=7.5u l=4u
X138 vss.t47 a_4818_4945# a_4818_4945# vss.t43 sg13_hv_nmos ad=0.2375p pd=1.63u as=0.2375p ps=1.63u w=1.25u l=4u
X139 a_442_5111# a_442_5111# a_442_5111# vss.t3 sg13_hv_nmos ad=0.2375p pd=1.63u as=0 ps=0 w=1.25u l=0.45u
X140 vdd vdd vdd vdd sg13_hv_pmos ad=1.425p pd=7.88u as=0 ps=0 w=7.5u l=0.4u
X141 a_592_286# ibias vss.t72 vss.t102 sg13_hv_nmos ad=0.475p pd=2.88u as=0.475p ps=2.88u w=2.5u l=4u
X142 vss.t32 a_9288_5041# out.t0 vss.t31 sg13_hv_nmos ad=0.475p pd=2.88u as=0.475p ps=2.88u w=2.5u l=1u
X143 out a_1076_5541# vdd vdd sg13_hv_pmos ad=1.425p pd=7.88u as=1.425p ps=7.88u w=7.5u l=1u
X144 a_1076_5541# a_1076_5541# a_1076_5541# vdd sg13_hv_pmos ad=2.55p pd=15.68u as=0 ps=0 w=7.5u l=1u
X145 vss.t59 a_8488_4945# a_8488_4945# vss.t55 sg13_hv_nmos ad=0.2375p pd=1.63u as=0.2375p ps=1.63u w=1.25u l=4u
X146 a_1076_5541# inp a_442_5111# vss.t62 sg13_hv_nmos ad=0.2375p pd=1.63u as=0.2375p ps=1.63u w=1.25u l=2u
X147 a_6733_6167# a_6733_6167# a_9508_346# vdd sg13_hv_pmos ad=1.425p pd=7.88u as=1.425p ps=7.88u w=7.5u l=1u
X148 w_8388_2366# inp a_9288_5041# w_8388_2366# sg13_hv_pmos ad=0.7125p pd=4.13u as=0.7125p ps=4.13u w=3.75u l=2u
X149 a_6733_6167# a_5933_6071# vss.t14 vss.t13 sg13_hv_nmos ad=0.475p pd=2.88u as=0.475p ps=2.88u w=2.5u l=4u
X150 vdd a_1076_5541# out vdd sg13_hv_pmos ad=1.425p pd=7.88u as=1.425p ps=7.88u w=7.5u l=1u
C0 a_1076_5541# out 2.50637f
C1 a_12967_3523# a_9288_5041# 0.05266f
C2 a_592_286# a_5933_6071# 1.18671f
C3 inp a_592_286# 0.43322f
C4 a_12967_5343# a_14767_5343# 0.08145f
C5 a_14767_5343# a_1076_5541# 0.08664f
C6 a_9288_5041# inn 0.32254f
C7 ibias a_592_286# 0.80911f
C8 vdd inn 0.30448f
C9 a_14767_2795# a_9288_5041# 1.0758f
C10 a_592_286# w_8388_2366# 3.48603f
C11 a_12967_3887# a_1076_5541# 0.03091f
C12 a_12967_3159# a_12967_2795# 0.20927f
C13 a_6733_6167# a_1392_382# 0.636f
C14 vdd a_14767_2795# 0.31715f
C15 a_12881_4979# a_12967_5343# 0.03876f
C16 inp a_1076_5541# 0.6563f
C17 a_1076_5541# a_5933_6071# 0.13572f
C18 a_12881_4979# a_1076_5541# 0.02632f
C19 a_12967_5707# a_14767_5343# 0.04289f
C20 a_12881_3523# a_12967_3887# 0.03876f
C21 a_12967_3159# a_1076_5541# 0.02269f
C22 vdd a_4818_4945# 0.15626f
C23 a_12881_4251# a_12967_4251# 0.03876f
C24 a_1076_5541# w_8388_2366# 0.18098f
C25 a_12881_3523# w_8388_2366# 0.04192f
C26 a_14767_4615# a_12967_4615# 0.03876f
C27 vdd a_3520_5051# 20.341f
C28 a_12967_5343# a_12967_4979# 0.20927f
C29 a_12967_4979# a_1076_5541# 0.04703f
C30 a_9288_5041# out 1.36469f
C31 a_8488_4945# a_1392_382# 0.3486f
C32 vdd out 2.11845f
C33 a_9508_346# a_592_286# 0.04283f
C34 a_6733_6167# a_592_286# 0.08698f
C35 a_442_5111# inn 0.97231f
C36 a_14767_5343# a_9288_5041# 0.04052f
C37 a_14767_2795# a_12967_2431# 0.0255f
C38 a_12967_3887# a_9288_5041# 0.17703f
C39 a_9508_346# a_1076_5541# 0.0855f
C40 a_442_5111# a_4818_4945# 1.04724f
C41 a_6733_6167# a_1076_5541# 1.62117f
C42 a_9288_5041# a_5933_6071# 0.61977f
C43 inp a_9288_5041# 1.40218f
C44 a_12967_3159# a_9288_5041# 0.04099f
C45 inp vdd 0.12326f
C46 vdd a_5933_6071# 0.79989f
C47 w_8388_2366# a_9288_5041# 1.17037f
C48 a_3520_5051# a_442_5111# 0.44282f
C49 vdd w_8388_2366# 1.65987f
C50 a_592_2733# a_1392_382# 0.08807f
C51 a_8488_4945# a_592_286# 0.09532f
C52 a_12967_4251# a_1076_5541# 0.19604f
C53 a_12967_3523# a_14767_2795# 0.04329f
C54 a_8488_4945# a_11355_6131# 0.05561f
C55 a_14767_4615# a_14767_5343# 0.10346f
C56 a_1392_382# a_592_286# 1.91613f
C57 a_12881_4251# a_1076_5541# 0.04323f
C58 a_4818_4945# inn 0.02908f
C59 a_6733_6167# a_9288_5041# 0.62999f
C60 a_442_5111# a_5933_6071# 0.06572f
C61 inp a_442_5111# 0.95508f
C62 a_12881_3523# a_12881_4251# 0.01672f
C63 a_592_2733# a_592_286# 0.62365f
C64 vdd a_9508_346# 2.73634f
C65 vdd a_6733_6167# 3.98013f
C66 ibias a_442_5111# 0.83126f
C67 a_1076_5541# a_1392_382# 1.88462f
C68 a_442_5111# w_8388_2366# 0.01993f
C69 a_3520_5051# inn 0.41738f
C70 a_12967_4615# a_14767_5343# 0.04329f
C71 a_1392_382# a_11355_6131# 0.61898f
C72 a_592_2733# a_1076_5541# 3.45441f
C73 a_12967_5707# a_1392_382# 0.05833f
C74 a_3520_5051# a_4818_4945# 0.78505f
C75 a_12967_4251# a_9288_5041# 0.01473f
C76 a_14767_2795# out 0.33643p
C77 a_14767_4615# a_12967_4979# 0.03876f
C78 a_8488_4945# a_9288_5041# 1.38579f
C79 a_12967_3887# a_12967_3523# 0.20927f
C80 a_14767_3159# a_9288_5041# 0.02632f
C81 a_12881_2795# a_12967_3159# 0.03876f
C82 a_12967_3159# a_12967_3523# 0.20927f
C83 a_12881_2795# w_8388_2366# 0.03879f
C84 a_1076_5541# a_592_286# 1.93392f
C85 a_12967_4615# a_12967_4979# 0.20927f
C86 a_5933_6071# inn 0.02645f
C87 inp inn 5.07118f
C88 a_442_5111# a_6733_6167# 0.01655f
C89 ibias inn 0.12725f
C90 a_12967_2795# a_1076_5541# 0.02684f
C91 a_12967_3159# a_14767_2795# 0.04329f
C92 w_8388_2366# inn 6.13335f
C93 inp a_4818_4945# 0.23197f
C94 a_4818_4945# a_5933_6071# 1.14036f
C95 a_12967_5343# a_1076_5541# 0.04008f
C96 a_1392_382# a_9288_5041# 1.22566f
C97 vdd a_1392_382# 2.12514f
C98 ibias a_4818_4945# 0.44789f
C99 a_12881_3523# a_1076_5541# 0.02244f
C100 a_4818_4945# w_8388_2366# 0.54521f
C101 inp a_3520_5051# 0.11543f
C102 a_12967_5707# a_12967_5343# 0.20927f
C103 a_592_2733# vdd 19.8957f
C104 a_14767_5343# out 0.33471p
C105 ibias a_3520_5051# 0.01869f
C106 a_3520_5051# w_8388_2366# 1.95611f
C107 a_12967_4615# a_12967_4251# 0.20927f
C108 a_6733_6167# inn 0.0433f
C109 vdd a_592_286# 39.8003f
C110 a_12967_2795# a_9288_5041# 0.04495f
C111 a_6733_6167# a_4818_4945# 0.30974f
C112 inp a_5933_6071# 0.07536f
C113 a_1076_5541# a_9288_5041# 3.56717f
C114 ibias inp 0.16028f
C115 vdd a_1076_5541# 16.4562f
C116 a_12881_4251# a_12967_4615# 0.03876f
C117 a_12881_3523# a_9288_5041# 0.02692f
C118 a_592_2733# a_442_5111# 0.34884f
C119 a_11355_6131# a_9288_5041# 0.08475f
C120 w_8388_2366# a_5933_6071# 0.43298f
C121 inp w_8388_2366# 6.12256f
C122 a_12967_3523# a_14767_3159# 0.03876f
C123 a_3520_5051# a_6733_6167# 0.12248f
C124 a_12967_5707# a_9288_5041# 0.02198f
C125 a_14767_5343# a_12967_4979# 0.04329f
C126 a_8488_4945# inn 1.31946f
C127 a_12881_4979# a_12967_4979# 0.03876f
C128 a_14767_3159# a_14767_2795# 0.1032f
C129 a_8488_4945# a_4818_4945# 0.28196f
C130 a_442_5111# a_592_286# 0.77885f
C131 a_12967_2795# a_12967_2431# 0.20927f
C132 a_1392_382# inn 0.1848f
C133 inp a_9508_346# 0.01072f
C134 inp a_6733_6167# 0.04296f
C135 a_6733_6167# a_5933_6071# 2.25971f
C136 a_12967_2431# a_1076_5541# 0.09942f
C137 a_442_5111# a_1076_5541# 0.26405f
C138 a_14767_4615# a_1076_5541# 0.02542f
C139 vdd a_9288_5041# 0.66411f
C140 a_592_2733# inn 1.36419f
C141 a_9508_346# w_8388_2366# 0.01462f
C142 a_6733_6167# w_8388_2366# 0.34064f
C143 a_12967_4251# a_14767_5343# 0.01305f
C144 a_12967_3887# a_12967_4251# 0.20927f
C145 a_3520_5051# a_1392_382# 0.18479f
C146 a_12967_4615# a_1076_5541# 0.06311f
C147 a_592_2733# a_3520_5051# 0.11013f
C148 a_12881_2795# a_12967_2795# 0.03876f
C149 inp a_8488_4945# 0.6188f
C150 a_8488_4945# a_5933_6071# 1.42862f
C151 a_592_286# inn 0.18492f
C152 a_12881_2795# a_1076_5541# 0.02347f
C153 a_12967_3523# a_1076_5541# 0.02011f
C154 a_12967_3159# a_14767_3159# 0.03876f
C155 a_8488_4945# w_8388_2366# 1.83939f
C156 a_12881_3523# a_12881_2795# 0.01672f
C157 a_12881_3523# a_12967_3523# 0.03876f
C158 a_4818_4945# a_592_286# 0.57749f
C159 a_12881_4251# a_12881_4979# 0.01672f
C160 a_12967_2795# a_14767_2795# 0.08145f
C161 a_6733_6167# a_9508_346# 1.06577f
C162 a_1076_5541# inn 0.39797f
C163 a_12967_2431# a_9288_5041# 0.01328f
C164 a_14767_2795# a_1076_5541# 0.08049f
C165 a_12881_4251# w_8388_2366# 0.04f
C166 vdd a_442_5111# 0.03377f
C167 a_3520_5051# a_592_286# 0.37968f
C168 a_1392_382# a_5933_6071# 0.07674f
C169 inp a_1392_382# 0.20624f
C170 inp a_592_2733# 0.31895f
C171 a_1392_382# w_8388_2366# 1.34032f
C172 a_3520_5051# a_1076_5541# 0.20675f
C173 ibias a_592_2733# 0.04618f
R0 out.t1 out.t0 3.11994
R1 out out.t1 1.21737
R2 vss.n375 vss.n374 55358.3
R3 vss.n6 vss.t97 22.054
R4 vss.n4 vss.n18 0.0396081
R5 vss.n1 vss.n155 93.268
R6 vss.t31 vss.n7 25.2567
R7 vss.t30 vss.n370 88.8232
R8 vss.t1 vss.n157 85.7681
R9 vss.n372 vss.n371 85.2665
R10 vss.t87 vss.n2 96.4067
R11 vss.t29 vss.n369 82.9002
R12 vss.t0 vss.n0 82.4923
R13 vss.n253 vss.n106 80.4072
R14 vss.n252 vss.n75 80.4072
R15 vss.n251 vss.n105 80.4072
R16 vss.n250 vss.n76 80.4072
R17 vss.n246 vss.n104 80.4072
R18 vss.n245 vss.n77 80.4072
R19 vss.n244 vss.n103 80.4072
R20 vss.n243 vss.n78 80.4072
R21 vss.n242 vss.n102 80.4072
R22 vss.n241 vss.n79 80.4072
R23 vss.n240 vss.n101 80.4072
R24 vss.n237 vss.n81 80.4072
R25 vss.n236 vss.n99 80.4072
R26 vss.n235 vss.n82 80.4072
R27 vss.n234 vss.n98 80.4072
R28 vss.n233 vss.n83 80.4072
R29 vss.n232 vss.n97 80.4072
R30 vss.n231 vss.n84 80.4072
R31 vss.n229 vss.n85 80.4072
R32 vss.n228 vss.n95 80.4072
R33 vss.n225 vss.n87 80.4072
R34 vss.n224 vss.n93 80.4072
R35 vss.n222 vss.n92 80.4072
R36 vss.n221 vss.n89 80.4072
R37 vss.n220 vss.n91 80.4072
R38 vss.n134 vss.n46 78.7062
R39 vss.n135 vss.n45 78.7062
R40 vss.n138 vss.n42 78.7062
R41 vss.n139 vss.n41 78.7062
R42 vss.n140 vss.n40 78.7062
R43 vss.n141 vss.n39 78.7062
R44 vss.n142 vss.n38 78.7062
R45 vss.n143 vss.n37 78.7062
R46 vss.n145 vss.n35 78.7062
R47 vss.n146 vss.n34 78.7062
R48 vss.n147 vss.n33 78.7062
R49 vss.n148 vss.n32 78.7062
R50 vss.n150 vss.n30 78.7062
R51 vss.n151 vss.n29 78.7062
R52 vss.n152 vss.n28 78.7062
R53 vss.n6 vss.t22 31.4664
R54 vss.t28 vss.n368 76.9772
R55 vss.n5 vss.t24 32.2586
R56 vss.t27 vss.n367 71.0542
R57 vss.n4 vss.t105 28.8749
R58 vss.n367 vss.t26 65.1312
R59 vss.t26 vss.n5 65.2162
R60 vss.t78 vss.n96 63.7713
R61 vss.n13 vss.n4 8.88535
R62 vss.t4 vss.n1 60.4759
R63 vss.n254 vss.t19 59.6123
R64 vss.n368 vss.t27 59.2082
R65 vss.n5 vss.n4 0.0714014
R66 vss.t107 vss.n156 58.2211
R67 vss.n137 vss.t60 57.718
R68 vss.n144 vss.t61 57.718
R69 vss.n0 vss.t4 57.5678
R70 vss.t103 vss.n44 56.4063
R71 vss.n157 vss.t107 55.5976
R72 vss.n369 vss.t28 53.2852
R73 vss.n8 vss.n14 14.1134
R74 vss.n117 vss.n62 52.471
R75 vss.n118 vss.n61 52.471
R76 vss.n119 vss.n60 52.471
R77 vss.n120 vss.n59 52.471
R78 vss.n121 vss.n58 52.471
R79 vss.n122 vss.n57 52.471
R80 vss.n124 vss.n55 52.471
R81 vss.n125 vss.n54 52.471
R82 vss.n126 vss.n53 52.471
R83 vss.n127 vss.n52 52.471
R84 vss.n128 vss.n51 52.471
R85 vss.n129 vss.n50 52.471
R86 vss.n131 vss.n48 52.471
R87 vss.n132 vss.n47 52.471
R88 vss.n219 vss.t11 51.2944
R89 vss.t55 vss.n94 49.9081
R90 vss.n133 vss.n47 49.0388
R91 vss.n238 vss.t20 48.5218
R92 vss.n370 vss.t29 47.3622
R93 vss.n303 vss.n13 52.9475
R94 vss.n312 vss.n158 47.2239
R95 vss.n302 vss.n159 47.2239
R96 vss.n313 vss.n160 47.2239
R97 vss.n301 vss.n161 47.2239
R98 vss.n314 vss.n162 47.2239
R99 vss.n300 vss.n163 47.2239
R100 vss.n316 vss.n166 47.2239
R101 vss.n298 vss.n167 47.2239
R102 vss.n317 vss.n168 47.2239
R103 vss.n297 vss.n169 47.2239
R104 vss.n318 vss.n170 47.2239
R105 vss.n296 vss.n171 47.2239
R106 vss.n319 vss.n172 47.2239
R107 vss.n295 vss.n173 47.2239
R108 vss.n320 vss.n174 47.2239
R109 vss.n294 vss.n175 47.2239
R110 vss.n321 vss.n176 47.2239
R111 vss.n322 vss.n178 47.2239
R112 vss.n292 vss.n179 47.2239
R113 vss.n323 vss.n180 47.2239
R114 vss.n291 vss.n181 47.2239
R115 vss.n324 vss.n182 47.2239
R116 vss.n290 vss.n183 47.2239
R117 vss.n325 vss.n184 47.2239
R118 vss.n289 vss.n185 47.2239
R119 vss.n326 vss.n186 47.2239
R120 vss.n288 vss.n187 47.2239
R121 vss.n327 vss.n188 47.2239
R122 vss.n287 vss.n189 47.2239
R123 vss.n328 vss.n190 47.2239
R124 vss.n286 vss.n191 47.2239
R125 vss.n329 vss.n192 47.2239
R126 vss.n330 vss.n194 47.2239
R127 vss.n284 vss.n195 47.2239
R128 vss.n331 vss.n196 47.2239
R129 vss.n283 vss.n197 47.2239
R130 vss.n332 vss.n198 47.2239
R131 vss.n282 vss.n199 47.2239
R132 vss.n333 vss.n200 47.2239
R133 vss.n281 vss.n201 47.2239
R134 vss.n337 vss.n202 47.2239
R135 vss.n280 vss.n203 47.2239
R136 vss.n381 vss.n204 47.2239
R137 vss.n380 vss.n205 47.2239
R138 vss.n378 vss.n207 47.2239
R139 vss.n377 vss.n209 47.2239
R140 vss.n386 vss.n385 47.1354
R141 vss.n385 vss.n64 47.1354
R142 vss.n273 vss.n64 47.1354
R143 vss.n273 vss.n116 47.1354
R144 vss.n272 vss.n116 47.1354
R145 vss.n272 vss.n65 47.1354
R146 vss.n271 vss.n65 47.1354
R147 vss.n271 vss.n115 47.1354
R148 vss.n270 vss.n115 47.1354
R149 vss.n270 vss.n66 47.1354
R150 vss.n269 vss.n66 47.1354
R151 vss.n269 vss.n114 47.1354
R152 vss.n268 vss.n114 47.1354
R153 vss.n268 vss.n67 47.1354
R154 vss.n267 vss.n113 47.1354
R155 vss.n266 vss.n68 47.1354
R156 vss.n265 vss.n68 47.1354
R157 vss.n265 vss.n112 47.1354
R158 vss.n264 vss.n112 47.1354
R159 vss.n264 vss.n69 47.1354
R160 vss.n263 vss.n69 47.1354
R161 vss.n263 vss.n111 47.1354
R162 vss.n262 vss.n111 47.1354
R163 vss.n262 vss.n70 47.1354
R164 vss.n261 vss.n70 47.1354
R165 vss.n261 vss.n110 47.1354
R166 vss.n260 vss.n110 47.1354
R167 vss.n260 vss.n71 47.1354
R168 vss.n259 vss.n71 47.1354
R169 vss.n259 vss.n109 47.1354
R170 vss.n258 vss.n109 47.1354
R171 vss.n258 vss.n72 47.1354
R172 vss.n257 vss.n72 47.1354
R173 vss.n257 vss.n108 47.1354
R174 vss.n256 vss.n108 47.1354
R175 vss.n256 vss.n73 47.1354
R176 vss.n255 vss.n73 47.1354
R177 vss.n255 vss.n107 47.1354
R178 vss.t106 vss.n31 45.9122
R179 vss.t85 vss.n210 45.9122
R180 vss.n223 vss.t10 45.7491
R181 vss.n386 vss.t85 44.1834
R182 vss.t15 vss.n193 43.2887
R183 vss.n303 vss.n158 41.9769
R184 vss.n312 vss.n159 41.9769
R185 vss.n302 vss.n160 41.9769
R186 vss.n313 vss.n161 41.9769
R187 vss.n301 vss.n162 41.9769
R188 vss.n314 vss.n163 41.9769
R189 vss.n300 vss.n164 41.9769
R190 vss.n315 vss.n165 41.9769
R191 vss.n299 vss.n166 41.9769
R192 vss.n316 vss.n167 41.9769
R193 vss.n298 vss.n168 41.9769
R194 vss.n317 vss.n169 41.9769
R195 vss.n297 vss.n170 41.9769
R196 vss.n318 vss.n171 41.9769
R197 vss.n296 vss.n172 41.9769
R198 vss.n295 vss.n174 41.9769
R199 vss.n320 vss.n175 41.9769
R200 vss.n294 vss.n176 41.9769
R201 vss.n321 vss.n177 41.9769
R202 vss.n293 vss.n178 41.9769
R203 vss.n322 vss.n179 41.9769
R204 vss.n292 vss.n180 41.9769
R205 vss.n291 vss.n182 41.9769
R206 vss.n324 vss.n183 41.9769
R207 vss.n290 vss.n184 41.9769
R208 vss.n325 vss.n185 41.9769
R209 vss.n289 vss.n186 41.9769
R210 vss.n326 vss.n187 41.9769
R211 vss.n288 vss.n188 41.9769
R212 vss.n327 vss.n189 41.9769
R213 vss.n328 vss.n191 41.9769
R214 vss.n286 vss.n192 41.9769
R215 vss.n329 vss.n193 41.9769
R216 vss.n285 vss.n194 41.9769
R217 vss.n330 vss.n195 41.9769
R218 vss.n284 vss.n196 41.9769
R219 vss.n331 vss.n197 41.9769
R220 vss.n283 vss.n198 41.9769
R221 vss.n332 vss.n199 41.9769
R222 vss.n282 vss.n200 41.9769
R223 vss.n333 vss.n201 41.9769
R224 vss.n281 vss.n202 41.9769
R225 vss.n280 vss.n204 41.9769
R226 vss.n381 vss.n205 41.9769
R227 vss.n380 vss.n206 41.9769
R228 vss.n379 vss.n207 41.9769
R229 vss.n378 vss.n208 41.9769
R230 vss.n376 vss.n209 41.9769
R231 vss.n377 vss.n210 41.9769
R232 vss.n254 vss.t52 41.5901
R233 vss.n239 vss.t54 41.5901
R234 vss.n13 vss.t82 21.2527
R235 vss.n227 vss.t6 40.2038
R236 vss.t6 vss.n86 40.2038
R237 vss.n371 vss.t30 39.3632
R238 vss.n293 vss.t40 39.3534
R239 vss.n287 vss.t42 39.3534
R240 vss.n360 vss.t67 39.0202
R241 vss.n363 vss.t48 39.0202
R242 vss.t54 vss.n80 38.8175
R243 vss.n366 vss.t64 37.348
R244 vss.n117 vss.n63 36.7298
R245 vss.n118 vss.n62 36.7298
R246 vss.n120 vss.n60 36.7298
R247 vss.n121 vss.n59 36.7298
R248 vss.n122 vss.n58 36.7298
R249 vss.n123 vss.n57 36.7298
R250 vss.n125 vss.n55 36.7298
R251 vss.n126 vss.n54 36.7298
R252 vss.n127 vss.n53 36.7298
R253 vss.n128 vss.n52 36.7298
R254 vss.n129 vss.n51 36.7298
R255 vss.n130 vss.n50 36.7298
R256 vss.n131 vss.n49 36.7298
R257 vss.n132 vss.n48 36.7298
R258 vss.n319 vss.t75 36.7298
R259 vss.n4 vss.n7 0.585902
R260 vss.t13 vss.n181 35.4181
R261 vss.t33 vss.n12 11.5701
R262 vss.t10 vss.n88 34.6585
R263 vss.t71 vss.n63 34.1063
R264 vss.n156 vss.t0 33.2976
R265 vss.t65 vss.n364 33.1702
R266 vss.n119 vss.t2 32.7946
R267 vss.n149 vss.t106 32.7946
R268 vss.t17 vss.n206 32.7946
R269 vss.t20 vss.n100 31.8859
R270 vss.t68 vss.n361 31.514
R271 vss.t66 vss.n3 31.4979
R272 vss.n123 vss.t62 31.4828
R273 vss.n130 vss.t63 31.4828
R274 vss.n376 vss.n375 31.4828
R275 vss.n267 vss.t49 30.4996
R276 vss.n226 vss.t55 30.4996
R277 vss.t11 vss.n90 29.1133
R278 vss.n361 vss.t69 28.9915
R279 vss.n364 vss.t35 28.9868
R280 vss.n315 vss.t37 28.8593
R281 vss.n337 vss.t43 28.8593
R282 vss.n374 vss.n373 28.1986
R283 vss.t102 vss.n56 24.924
R284 vss.t108 vss.n165 24.924
R285 vss.t36 vss.n366 24.809
R286 vss.t18 vss.n113 23.568
R287 vss.n266 vss.t18 23.568
R288 vss.t69 vss.n360 23.1367
R289 vss.t35 vss.n363 23.1367
R290 vss.n133 vss.n46 22.8035
R291 vss.n374 vss.n3 22.7159
R292 vss.n136 vss.t103 22.3005
R293 vss.n299 vss.t108 22.3005
R294 vss.t5 vss.n18 17.3475
R295 vss.t62 vss.n56 20.9887
R296 vss.t63 vss.n49 20.9887
R297 vss.t60 vss.n43 20.9887
R298 vss.t61 vss.n36 20.9887
R299 vss.t19 vss.n74 20.7953
R300 vss.n359 vss.t66 20.7093
R301 vss.n362 vss.t68 20.7093
R302 vss.n365 vss.t65 19.0371
R303 vss.n14 vss.t71 27.0467
R304 vss.t37 vss.n164 18.3652
R305 vss.n4 vss.t12 11.8735
R306 vss.n153 vss.n4 17.0005
R307 vss.n4 vss.n388 17.0005
R308 vss.n4 vss.n24 17.0005
R309 vss.n26 vss.n4 17.0005
R310 vss.n17 vss.n4 8.49485
R311 vss.n16 vss.n17 0.0132937
R312 vss.n4 vss.n9 0.795252
R313 vss.n8 vss.n21 17.0005
R314 vss.n387 vss.n8 17.0005
R315 vss.n8 vss.n25 17.0005
R316 vss.n8 vss.n27 17.0005
R317 vss.n9 vss.n16 0.151894
R318 vss.n9 vss.n8 0.757513
R319 vss.n279 vss.t44 17.0005
R320 vss.t84 vss.t51 17.0005
R321 vss.n382 vss.n248 17.0005
R322 vss.n383 vss.n382 17.0005
R323 vss.n384 vss.n248 17.0005
R324 vss.n384 vss.n383 17.0005
R325 vss.t47 vss.t92 17.0005
R326 vss.n276 vss.t50 17.0005
R327 vss.n384 vss.n214 17.0005
R328 vss.n384 vss.n218 17.0005
R329 vss.n217 vss.t56 17.0005
R330 vss.t86 vss.t88 17.0005
R331 vss.t59 vss.t94 17.0005
R332 vss.n213 vss.t95 17.0005
R333 vss.n4 vss.n386 17.0005
R334 vss.n4 vss.n64 17.0005
R335 vss.n4 vss.n116 17.0005
R336 vss.n4 vss.n65 17.0005
R337 vss.n4 vss.n115 17.0005
R338 vss.n4 vss.n66 17.0005
R339 vss.n4 vss.n114 17.0005
R340 vss.n4 vss.n67 17.0005
R341 vss.n4 vss.n113 17.0005
R342 vss.n4 vss.n68 17.0005
R343 vss.n4 vss.n112 17.0005
R344 vss.n4 vss.n69 17.0005
R345 vss.n4 vss.n111 17.0005
R346 vss.n4 vss.n70 17.0005
R347 vss.n4 vss.n110 17.0005
R348 vss.n4 vss.n71 17.0005
R349 vss.n4 vss.n109 17.0005
R350 vss.n4 vss.n72 17.0005
R351 vss.n4 vss.n108 17.0005
R352 vss.n4 vss.n73 17.0005
R353 vss.n4 vss.n107 17.0005
R354 vss.n4 vss.n74 17.0005
R355 vss.n4 vss.n106 17.0005
R356 vss.n4 vss.n75 17.0005
R357 vss.n4 vss.n105 17.0005
R358 vss.n4 vss.n76 17.0005
R359 vss.n4 vss.n104 17.0005
R360 vss.n4 vss.n77 17.0005
R361 vss.n4 vss.n103 17.0005
R362 vss.n4 vss.n78 17.0005
R363 vss.n4 vss.n102 17.0005
R364 vss.n4 vss.n79 17.0005
R365 vss.n4 vss.n101 17.0005
R366 vss.n4 vss.n80 17.0005
R367 vss.n4 vss.n100 17.0005
R368 vss.n4 vss.n81 17.0005
R369 vss.n4 vss.n99 17.0005
R370 vss.n4 vss.n82 17.0005
R371 vss.n4 vss.n98 17.0005
R372 vss.n4 vss.n83 17.0005
R373 vss.n4 vss.n97 17.0005
R374 vss.n4 vss.n84 17.0005
R375 vss.n4 vss.n96 17.0005
R376 vss.n4 vss.n85 17.0005
R377 vss.n4 vss.n95 17.0005
R378 vss.n4 vss.n86 17.0005
R379 vss.n4 vss.n94 17.0005
R380 vss.n4 vss.n87 17.0005
R381 vss.n4 vss.n93 17.0005
R382 vss.n4 vss.n88 17.0005
R383 vss.n4 vss.n92 17.0005
R384 vss.n4 vss.n89 17.0005
R385 vss.n4 vss.n91 17.0005
R386 vss.n4 vss.n90 17.0005
R387 vss.n14 vss.n4 4.83305
R388 vss.n4 vss.n117 17.0005
R389 vss.n4 vss.n118 17.0005
R390 vss.n4 vss.n119 17.0005
R391 vss.n4 vss.n120 17.0005
R392 vss.n4 vss.n121 17.0005
R393 vss.n4 vss.n122 17.0005
R394 vss.n4 vss.n123 17.0005
R395 vss.n4 vss.n124 17.0005
R396 vss.n4 vss.n125 17.0005
R397 vss.n4 vss.n126 17.0005
R398 vss.n4 vss.n127 17.0005
R399 vss.n4 vss.n128 17.0005
R400 vss.n4 vss.n129 17.0005
R401 vss.n4 vss.n130 17.0005
R402 vss.n4 vss.n131 17.0005
R403 vss.n4 vss.n132 17.0005
R404 vss.n4 vss.n134 17.0005
R405 vss.n4 vss.n135 17.0005
R406 vss.n4 vss.n136 17.0005
R407 vss.n4 vss.n137 17.0005
R408 vss.n4 vss.n138 17.0005
R409 vss.n4 vss.n139 17.0005
R410 vss.n4 vss.n140 17.0005
R411 vss.n4 vss.n141 17.0005
R412 vss.n4 vss.n142 17.0005
R413 vss.n4 vss.n143 17.0005
R414 vss.n4 vss.n144 17.0005
R415 vss.n4 vss.n145 17.0005
R416 vss.n4 vss.n146 17.0005
R417 vss.n4 vss.n147 17.0005
R418 vss.n4 vss.n148 17.0005
R419 vss.n4 vss.n149 17.0005
R420 vss.n4 vss.n150 17.0005
R421 vss.n4 vss.n151 17.0005
R422 vss.n4 vss.n152 17.0005
R423 vss.n4 vss.n158 17.0005
R424 vss.n4 vss.n159 17.0005
R425 vss.n4 vss.n160 17.0005
R426 vss.n4 vss.n161 17.0005
R427 vss.n4 vss.n162 17.0005
R428 vss.n4 vss.n163 17.0005
R429 vss.n4 vss.n164 17.0005
R430 vss.n4 vss.n165 17.0005
R431 vss.n4 vss.n166 17.0005
R432 vss.n4 vss.n167 17.0005
R433 vss.n4 vss.n168 17.0005
R434 vss.n4 vss.n169 17.0005
R435 vss.n4 vss.n170 17.0005
R436 vss.n4 vss.n171 17.0005
R437 vss.n4 vss.n172 17.0005
R438 vss.n4 vss.n173 17.0005
R439 vss.n4 vss.n174 17.0005
R440 vss.n4 vss.n175 17.0005
R441 vss.n4 vss.n176 17.0005
R442 vss.n4 vss.n177 17.0005
R443 vss.n4 vss.n178 17.0005
R444 vss.n4 vss.n179 17.0005
R445 vss.n4 vss.n180 17.0005
R446 vss.n4 vss.n181 17.0005
R447 vss.n4 vss.n182 17.0005
R448 vss.n4 vss.n183 17.0005
R449 vss.n4 vss.n184 17.0005
R450 vss.n4 vss.n185 17.0005
R451 vss.n4 vss.n186 17.0005
R452 vss.n4 vss.n187 17.0005
R453 vss.n4 vss.n188 17.0005
R454 vss.n4 vss.n189 17.0005
R455 vss.n4 vss.n190 17.0005
R456 vss.n4 vss.n191 17.0005
R457 vss.n4 vss.n192 17.0005
R458 vss.n4 vss.n193 17.0005
R459 vss.n4 vss.n194 17.0005
R460 vss.n4 vss.n195 17.0005
R461 vss.n4 vss.n196 17.0005
R462 vss.n4 vss.n197 17.0005
R463 vss.n4 vss.n198 17.0005
R464 vss.n4 vss.n199 17.0005
R465 vss.n4 vss.n200 17.0005
R466 vss.n4 vss.n201 17.0005
R467 vss.n4 vss.n202 17.0005
R468 vss.n4 vss.n203 17.0005
R469 vss.n4 vss.n204 17.0005
R470 vss.n4 vss.n205 17.0005
R471 vss.n4 vss.n206 17.0005
R472 vss.n4 vss.n207 17.0005
R473 vss.n4 vss.n208 17.0005
R474 vss.n4 vss.n209 17.0005
R475 vss.n4 vss.n210 17.0005
R476 vss.n8 vss.n31 8.49976
R477 vss.n8 vss.n35 8.49652
R478 vss.n8 vss.n41 8.49702
R479 vss.n8 vss.n42 8.49851
R480 vss.n8 vss.n43 8.49751
R481 vss.n8 vss.n44 8.49796
R482 vss.n8 vss.n60 8.49801
R483 vss.n8 vss.n63 8.49746
R484 vss.n28 vss.n8 8.4958
R485 vss.n29 vss.n8 8.49555
R486 vss.n30 vss.n8 8.49531
R487 vss.n32 vss.n8 8.49506
R488 vss.n33 vss.n8 8.49482
R489 vss.n34 vss.n8 8.49457
R490 vss.n36 vss.n8 8.49432
R491 vss.n37 vss.n8 8.49408
R492 vss.n38 vss.n8 8.49776
R493 vss.n39 vss.n8 8.49677
R494 vss.n40 vss.n8 8.49876
R495 vss.n45 vss.n8 8.49384
R496 vss.n46 vss.n8 8.49359
R497 vss.n47 vss.n8 8.49335
R498 vss.n48 vss.n8 8.49311
R499 vss.n49 vss.n8 8.49286
R500 vss.n50 vss.n8 8.49826
R501 vss.n51 vss.n8 8.49727
R502 vss.n52 vss.n8 8.49262
R503 vss.n53 vss.n8 8.49238
R504 vss.n54 vss.n8 8.499
R505 vss.n55 vss.n8 8.49214
R506 vss.n56 vss.n8 8.4919
R507 vss.n57 vss.n8 8.49166
R508 vss.n58 vss.n8 8.49771
R509 vss.n59 vss.n8 8.49142
R510 vss.n61 vss.n8 8.49627
R511 vss.n62 vss.n8 8.49118
R512 vss.n382 vss.n311 17.0005
R513 vss.n382 vss.n307 17.0005
R514 vss.n306 vss.t83 17.0005
R515 vss.t81 vss.t39 17.0005
R516 vss.t91 vss.t89 17.0005
R517 vss.n310 vss.t38 17.0005
R518 vss.t21 vss.n19 4.24098
R519 vss.t21 vss.t77 17.0005
R520 vss.t79 vss.t80 17.0005
R521 vss.t96 vss.t23 17.0005
R522 vss.t101 vss.t99 17.0005
R523 vss.t76 vss.t74 17.0005
R524 vss.n343 vss.t14 17.0005
R525 vss.t73 vss.t70 17.0005
R526 vss.n392 vss.t72 17.0005
R527 vss.t49 vss.n67 16.6364
R528 vss.n230 vss.t78 16.6364
R529 vss.n375 vss.n208 15.7416
R530 vss.t64 vss.n365 14.8603
R531 vss.n4 vss.n12 0.0408726
R532 vss.n379 vss.t17 14.4299
R533 vss.n253 vss.n74 13.8637
R534 vss.n252 vss.n106 13.8637
R535 vss.n251 vss.n75 13.8637
R536 vss.n250 vss.n105 13.8637
R537 vss.n246 vss.n76 13.8637
R538 vss.n245 vss.n104 13.8637
R539 vss.n244 vss.n77 13.8637
R540 vss.n243 vss.n103 13.8637
R541 vss.n242 vss.n78 13.8637
R542 vss.n241 vss.n102 13.8637
R543 vss.n240 vss.n79 13.8637
R544 vss.n239 vss.n101 13.8637
R545 vss.n238 vss.n80 13.8637
R546 vss.n237 vss.n100 13.8637
R547 vss.n236 vss.n81 13.8637
R548 vss.n235 vss.n99 13.8637
R549 vss.n234 vss.n82 13.8637
R550 vss.n233 vss.n98 13.8637
R551 vss.n232 vss.n83 13.8637
R552 vss.n231 vss.n97 13.8637
R553 vss.n230 vss.n84 13.8637
R554 vss.n229 vss.n96 13.8637
R555 vss.n228 vss.n85 13.8637
R556 vss.n227 vss.n95 13.8637
R557 vss.n226 vss.n86 13.8637
R558 vss.n225 vss.n94 13.8637
R559 vss.n224 vss.n87 13.8637
R560 vss.n223 vss.n93 13.8637
R561 vss.n222 vss.n88 13.8637
R562 vss.n221 vss.n92 13.8637
R563 vss.n220 vss.n89 13.8637
R564 vss.n219 vss.n91 13.8637
R565 vss.t67 vss.n359 13.188
R566 vss.t48 vss.n362 13.188
R567 vss.t43 vss.n203 13.1181
R568 vss.t87 vss.n90 12.4774
R569 vss.n124 vss.t102 11.8064
R570 vss.n373 vss.n372 11.4754
R571 vss.n134 vss.n45 10.4946
R572 vss.n135 vss.n44 10.4946
R573 vss.n136 vss.n43 10.4946
R574 vss.n137 vss.n42 10.4946
R575 vss.n138 vss.n41 10.4946
R576 vss.n139 vss.n40 10.4946
R577 vss.n140 vss.n39 10.4946
R578 vss.n141 vss.n38 10.4946
R579 vss.n142 vss.n37 10.4946
R580 vss.n143 vss.n36 10.4946
R581 vss.n144 vss.n35 10.4946
R582 vss.n145 vss.n34 10.4946
R583 vss.n146 vss.n33 10.4946
R584 vss.n147 vss.n32 10.4946
R585 vss.n149 vss.n30 10.4946
R586 vss.n150 vss.n29 10.4946
R587 vss.n151 vss.n28 10.4946
R588 vss.n155 vss.n152 10.4946
R589 vss.n154 vss.n15 0.999023
R590 vss.n382 vss.n381 8.5005
R591 vss.n382 vss.n280 8.5005
R592 vss.n382 vss.n337 8.5005
R593 vss.n382 vss.n281 8.5005
R594 vss.n382 vss.n333 8.5005
R595 vss.n382 vss.n282 8.5005
R596 vss.n382 vss.n332 8.5005
R597 vss.n382 vss.n283 8.5005
R598 vss.n382 vss.n331 8.5005
R599 vss.n382 vss.n376 8.5005
R600 vss.n382 vss.n378 8.5005
R601 vss.n382 vss.n379 8.5005
R602 vss.n382 vss.n380 8.5005
R603 vss.n382 vss.n377 8.5005
R604 vss.n385 vss.n384 8.5005
R605 vss.n384 vss.n219 8.5005
R606 vss.n384 vss.n220 8.5005
R607 vss.n384 vss.n221 8.5005
R608 vss.n384 vss.n222 8.5005
R609 vss.n384 vss.n223 8.5005
R610 vss.n384 vss.n224 8.5005
R611 vss.n384 vss.n225 8.5005
R612 vss.n384 vss.n226 8.5005
R613 vss.n384 vss.n227 8.5005
R614 vss.n384 vss.n228 8.5005
R615 vss.n384 vss.n229 8.5005
R616 vss.n384 vss.n230 8.5005
R617 vss.n384 vss.n231 8.5005
R618 vss.n384 vss.n232 8.5005
R619 vss.n384 vss.n233 8.5005
R620 vss.n384 vss.n234 8.5005
R621 vss.n384 vss.n235 8.5005
R622 vss.n384 vss.n236 8.5005
R623 vss.n384 vss.n237 8.5005
R624 vss.n384 vss.n238 8.5005
R625 vss.n384 vss.n239 8.5005
R626 vss.n384 vss.n240 8.5005
R627 vss.n384 vss.n241 8.5005
R628 vss.n384 vss.n242 8.5005
R629 vss.n384 vss.n243 8.5005
R630 vss.n384 vss.n244 8.5005
R631 vss.n384 vss.n245 8.5005
R632 vss.n384 vss.n246 8.5005
R633 vss.n384 vss.n250 8.5005
R634 vss.n384 vss.n251 8.5005
R635 vss.n384 vss.n252 8.5005
R636 vss.n384 vss.n253 8.5005
R637 vss.n384 vss.n254 8.5005
R638 vss.n384 vss.n255 8.5005
R639 vss.n384 vss.n256 8.5005
R640 vss.n384 vss.n257 8.5005
R641 vss.n384 vss.n258 8.5005
R642 vss.n384 vss.n259 8.5005
R643 vss.n384 vss.n260 8.5005
R644 vss.n384 vss.n261 8.5005
R645 vss.n384 vss.n262 8.5005
R646 vss.n384 vss.n263 8.5005
R647 vss.n384 vss.n264 8.5005
R648 vss.n384 vss.n265 8.5005
R649 vss.n384 vss.n266 8.5005
R650 vss.n384 vss.n267 8.5005
R651 vss.n384 vss.n268 8.5005
R652 vss.n384 vss.n269 8.5005
R653 vss.n384 vss.n270 8.5005
R654 vss.n384 vss.n271 8.5005
R655 vss.n384 vss.n272 8.5005
R656 vss.n384 vss.n273 8.5005
R657 vss.n382 vss.n284 8.5005
R658 vss.n382 vss.n330 8.5005
R659 vss.n382 vss.n285 8.5005
R660 vss.n382 vss.n329 8.5005
R661 vss.n382 vss.n286 8.5005
R662 vss.n382 vss.n328 8.5005
R663 vss.n382 vss.n287 8.5005
R664 vss.n382 vss.n327 8.5005
R665 vss.n382 vss.n288 8.5005
R666 vss.n382 vss.n326 8.5005
R667 vss.n382 vss.n289 8.5005
R668 vss.n382 vss.n325 8.5005
R669 vss.n382 vss.n290 8.5005
R670 vss.n382 vss.n324 8.5005
R671 vss.n382 vss.n291 8.5005
R672 vss.n382 vss.n323 8.5005
R673 vss.n382 vss.n292 8.5005
R674 vss.n382 vss.n322 8.5005
R675 vss.n382 vss.n293 8.5005
R676 vss.n382 vss.n321 8.5005
R677 vss.n382 vss.n294 8.5005
R678 vss.n382 vss.n320 8.5005
R679 vss.n382 vss.n295 8.5005
R680 vss.n382 vss.n319 8.5005
R681 vss.n382 vss.n296 8.5005
R682 vss.n382 vss.n318 8.5005
R683 vss.n382 vss.n297 8.5005
R684 vss.n382 vss.n317 8.5005
R685 vss.n382 vss.n298 8.5005
R686 vss.n382 vss.n316 8.5005
R687 vss.n382 vss.n299 8.5005
R688 vss.n382 vss.n315 8.5005
R689 vss.n382 vss.n300 8.5005
R690 vss.n382 vss.n314 8.5005
R691 vss.n382 vss.n301 8.5005
R692 vss.n382 vss.n313 8.5005
R693 vss.n382 vss.n302 8.5005
R694 vss.n382 vss.n312 8.5005
R695 vss.n382 vss.n303 8.5005
R696 vss.t21 vss.n346 8.49188
R697 vss.n345 vss.t7 8.49188
R698 vss.t98 vss.n351 8.49188
R699 vss.n350 vss.t23 8.49188
R700 vss.n356 vss.t32 8.49188
R701 vss.t101 vss.n355 8.49188
R702 vss.n347 vss.t7 8.49176
R703 vss.t98 vss.n349 8.49176
R704 vss.t32 vss.n354 8.49176
R705 vss.t9 vss.n10 3.42543
R706 vss.n11 vss.n10 0.0620578
R707 vss.n342 vss.t76 8.49087
R708 vss.n341 vss.t14 8.49087
R709 vss.n391 vss.t73 8.49087
R710 vss.n390 vss.t72 8.49087
R711 vss.t9 vss.n348 8.49074
R712 vss.t44 vss.n278 8.48783
R713 vss.t51 vss.n277 8.48783
R714 vss.n275 vss.t47 8.48783
R715 vss.n274 vss.t50 8.48783
R716 vss.t56 vss.n216 8.48783
R717 vss.t88 vss.n215 8.48783
R718 vss.n212 vss.t59 8.48783
R719 vss.n211 vss.t95 8.48783
R720 vss.t83 vss.n305 8.48783
R721 vss.t39 vss.n304 8.48783
R722 vss.n309 vss.t91 8.48783
R723 vss.n308 vss.t38 8.48783
R724 vss.t40 vss.n177 7.87107
R725 vss.n148 vss.t3 6.55931
R726 vss.n323 vss.t13 6.55931
R727 vss.n352 vss.t98 5.68329
R728 vss.n357 vss.t32 5.68329
R729 vss.n19 vss.t7 5.6831
R730 vss.n10 vss.t80 2.81683
R731 vss.t52 vss.n107 5.54579
R732 vss.t75 vss.n173 5.24755
R733 vss.t34 vss.n11 4.4755
R734 vss.t25 vss.n353 4.4755
R735 vss.n338 vss.n358 4.4755
R736 vss.n22 vss.n344 4.4755
R737 vss.t104 vss.n393 4.4755
R738 vss.t14 vss.n340 4.25206
R739 vss.t72 vss.n389 4.25206
R740 vss.t76 vss.n340 4.25175
R741 vss.t73 vss.n389 4.25175
R742 vss.n352 vss.t23 4.24047
R743 vss.n357 vss.t101 4.24047
R744 vss.n339 vss.n20 4.1005
R745 vss.t2 vss.n61 3.93579
R746 vss.t3 vss.n31 3.93579
R747 vss.n285 vss.t15 3.93579
R748 vss.t42 vss.n190 2.62402
R749 vss.n4 vss.n133 2.34678
R750 vss.n4 vss.n156 2.34678
R751 vss.n4 vss.n157 2.34678
R752 vss.n23 vss.n16 2.27125
R753 vss.t16 vss.n336 2.26086
R754 vss.n7 vss.n372 42.3704
R755 vss.n371 vss.n4 2.14665
R756 vss.n373 vss.n4 1.36272
R757 vss.n15 vss.n4 0.378423
R758 vss.n338 vss.n4 1.73609
R759 vss.n382 vss.n335 0.986957
R760 vss.n249 vss.t53 0.72601
R761 vss.t53 vss.n247 0.719068
R762 vss.t41 vss.n334 0.715539
R763 vss.n336 vss.t41 0.676742
R764 vss.n4 vss.n0 0.331038
R765 vss.t25 vss.t34 0.309901
R766 vss.n4 vss.n2 0.0952203
R767 vss.n2 vss.t8 26.3344
R768 vss.n6 vss.n4 0.036509
R769 vss.n336 vss.n335 0.253688
R770 vss.n154 vss.n8 1.40897
R771 vss.n335 vss.n249 0.243936
R772 vss.n22 vss.t104 0.231286
R773 vss.n339 vss.t16 0.135543
R774 vss.n4 vss.n3 0.120581
R775 vss.n360 vss.n4 0.120581
R776 vss.n363 vss.n4 0.120581
R777 vss.n364 vss.n4 0.120581
R778 vss.n366 vss.n4 0.120581
R779 vss.t36 vss.n12 27.395
R780 vss.n361 vss.n4 0.116916
R781 vss.n248 vss.n276 0.0899444
R782 vss.n383 vss.n279 0.0899444
R783 vss.n214 vss.n213 0.0899444
R784 vss.n218 vss.n217 0.0899444
R785 vss.n311 vss.n310 0.0899444
R786 vss.n307 vss.n306 0.0899444
R787 vss.n338 vss.t25 0.0835571
R788 vss.t16 vss.n22 0.0654286
R789 vss.n20 vss.n19 0.0444465
R790 vss.n275 vss.n274 0.054196
R791 vss.n278 vss.n277 0.054196
R792 vss.n212 vss.n211 0.054196
R793 vss.n216 vss.n215 0.054196
R794 vss.n309 vss.n308 0.054196
R795 vss.n305 vss.n304 0.054196
R796 vss.t34 vss.n339 0.0533429
R797 vss.n4 vss.n1 0.0475125
R798 vss.n18 vss.t1 30.3123
R799 vss.n353 vss.n352 0.0448653
R800 vss.n358 vss.n357 0.0448653
R801 vss.n348 vss.n11 0.0422843
R802 vss.n342 vss.n341 0.0420072
R803 vss.n391 vss.n390 0.0420072
R804 vss.n344 vss.n343 0.0410556
R805 vss.n393 vss.n392 0.0410556
R806 vss.n382 vss.t41 0.0383438
R807 vss.n344 vss.n340 0.0382434
R808 vss.n393 vss.n389 0.0382434
R809 vss.n347 vss.n346 0.0382103
R810 vss.n350 vss.n349 0.0382103
R811 vss.n355 vss.n354 0.0382103
R812 vss.n346 vss.n345 0.0379609
R813 vss.n351 vss.n350 0.0379609
R814 vss.n356 vss.n355 0.0379609
R815 vss.n359 vss.n4 0.0365679
R816 vss.n362 vss.n4 0.0365679
R817 vss.n365 vss.n4 0.0365679
R818 vss.n370 vss.n4 0.0363214
R819 vss.n369 vss.n4 0.0363214
R820 vss.n368 vss.n4 0.0363214
R821 vss.n367 vss.n4 0.0363214
R822 vss.n278 vss.t84 0.027348
R823 vss.n276 vss.n275 0.027348
R824 vss.t92 vss.n274 0.027348
R825 vss.n279 vss.n277 0.027348
R826 vss.n216 vss.t86 0.027348
R827 vss.n217 vss.n215 0.027348
R828 vss.n213 vss.n212 0.027348
R829 vss.t94 vss.n211 0.027348
R830 vss.n305 vss.t81 0.027348
R831 vss.n310 vss.n309 0.027348
R832 vss.t89 vss.n308 0.027348
R833 vss.n306 vss.n304 0.027348
R834 vss.n348 vss.t79 0.0215307
R835 vss.n343 vss.n342 0.0212536
R836 vss.t74 vss.n341 0.0212536
R837 vss.n392 vss.n391 0.0212536
R838 vss.t70 vss.n390 0.0212536
R839 vss.n345 vss.n20 0.0197304
R840 vss.n384 vss.t53 0.0194878
R841 vss.t77 vss.n347 0.0194799
R842 vss.n353 vss.n349 0.0194799
R843 vss.n358 vss.n354 0.0194799
R844 vss.n249 vss.n248 0.0193889
R845 vss.n383 vss.n249 0.0193889
R846 vss.n247 vss.n214 0.0193889
R847 vss.n247 vss.n218 0.0193889
R848 vss.n334 vss.n311 0.0193889
R849 vss.n334 vss.n307 0.0193889
R850 vss.n351 vss.t96 0.0192304
R851 vss.t99 vss.n356 0.0192304
R852 vss.n27 vss.n26 0.0160592
R853 vss.n25 vss.n24 0.0160592
R854 vss.n388 vss.n387 0.0160592
R855 vss.n153 vss.n21 0.0160592
R856 vss.n27 vss.n17 0.0223398
R857 vss.n26 vss.n25 0.00954605
R858 vss.n387 vss.n24 0.00954605
R859 vss.n388 vss.n21 0.00954605
R860 vss.n154 vss.n153 0.00954605
R861 vss.t104 vss.n23 0.00954286
R862 vss.n15 vss.n23 4.76502
R863 vss.n4 vss.t100 16.3868
R864 vss.n155 vss.n8 1.06517
R865 vss vss.n0 0.0005
C174 out vss 67.4847f
C175 inn vss 3.90159f
C176 inp vss 4.27882f
C177 ibias vss 12.9531f
C178 a_9508_346# vss 0.38118f ; **FLOATING
C179 a_14767_2795# vss 13.19872f ; **FLOATING
C180 a_12881_2795# vss 1.69786f ; **FLOATING
C181 a_14767_3159# vss 1.63674f ; **FLOATING
C182 a_12881_3523# vss 1.6197f ; **FLOATING
C183 a_12881_4251# vss 1.62754f ; **FLOATING
C184 a_14767_4615# vss 1.64562f ; **FLOATING
C185 a_14767_5343# vss 14.34004f ; **FLOATING
C186 a_12881_4979# vss 1.7587f ; **FLOATING
C187 a_3520_5051# vss 1.27229f ; **FLOATING
C188 a_592_2733# vss 1.52525f ; **FLOATING
C189 a_8488_4945# vss 11.0007f ; **FLOATING
C190 a_4818_4945# vss 11.9279f ; **FLOATING
C191 a_1076_5541# vss 4.9529f ; **FLOATING
C192 a_6733_6167# vss 1.97732f ; **FLOATING
C193 a_442_5111# vss 4.54669f ; **FLOATING
C194 a_592_286# vss 6.98885f ; **FLOATING
C195 a_1392_382# vss 3.46901f ; **FLOATING
C196 a_5933_6071# vss 12.1437f ; **FLOATING
C197 a_9288_5041# vss 11.75108f ; **FLOATING
C198 a_11355_6131# vss 1.64332f ; **FLOATING
C199 vss.t25 vss 2.07146f ; **FLOATING
C200 vss.t34 vss 2.10688f ; **FLOATING
C201 out.t0 vss 77.4888f ; **FLOATING
C202 out.t1 vss 0.56062p ; **FLOATING
.ends
