*=======================================================================================
* opamp_rtr_params.spice
* Seed / frozen design parameters for opamp_rtr.spice (PyOPUS designpar mirror)
*
* NOT included by opamp_rtr.spice during PyOPUS optimization (see note there).
* Standalone use: .include this file BEFORE opamp_rtr.spice in a manual deck.
* After optimization: paste the optimized values here to freeze the design.
*
* Values below are the winner of the 40-corner optimize_full_corner run
* (compute_results/optimize_full_corner.sqlite): gain 41.3 dB, ugbw 1.55 MHz,
* pm 71.0 deg, idd 327 uA, tracking error 1.1 mV, noise 25.4 uV, thd 4.3e-4,
* all worst-case over ff/fs/sf/ss/tt x 8 sub-corners.
* The four v_bias_*/v_ref_* voltages of that run are replaced here by the
* current-mode bias generator (w_bias_*/w_ref_*/i_ref) - see opamp_rtr.spice.
*=======================================================================================
* PMOS input pair
.param w_diff_p=1.53348e-05
.param l_diff_p=2.994e-06
* NMOS input pair
.param w_diff_n=3.84696e-05
.param l_diff_n=9.82978e-06
* Input tails
.param w_tail_p=6.46134e-06
.param w_tail_n=4.18012e-05
* Shared L of every current-source / mirror device (bias generator included):
* the mirror ratios are pure width ratios only because L is common
.param l_bias=3.64566e-06
* NMOS mirror load
.param w_load_n=2.1507e-06
.param l_load_n=4.95993e-06
* PMOS mirror load
.param w_load_p=2.45988e-05
.param l_load_p=1.37747e-06
* Output PMOS (was pinned at its 150u upper bound in the winning run)
.param w_out_p=1.49991e-04
.param l_out_p=6.25787e-07
* Output NMOS
.param w_out_n=5.809e-05
.param l_out_n=1.11464e-06
* Monticelli floating NMOS + N-stack diodes
.param w_ab_n=6.44967e-06
.param l_ab_n=1.17371e-06
* Monticelli floating PMOS + P-stack diodes
.param w_ab_p=1.35911e-06
.param l_ab_p=9.48156e-07
* I_ab feed (PMOS XM15/XM17/XM23) and sink (NMOS XM16/XM20/XM24)
.param w_ab_src=6.51943e-06
.param w_ab_snk=1.11079e-05
* Miller caps
.param c_miller_p=3.32491e-12
.param c_miller_n=8.8936e-13
* Constant-gm current switches
.param w_sw_p=3.59708e-05
.param w_sw_n=1.43106e-06
* gm-switch mirrors: diode (1) and output (2) devices; ratio w2/w1 sets how much
* the surviving pair is boosted (1x for weak inversion .. 3x for strong)
.param w_gmn1=2.86919e-06
.param w_gmn2=1.37553e-06
.param w_gmp1=9.34374e-07
.param w_gmp2=1.87399e-06
*=======================================================================================
* Current-mode bias generator (replaces the four distributed bias voltages).
* External reference current into the ibias pin; every branch of the generator
* carries i_ref, and each biased device mirrors it by W ratio at l_bias.
.param i_ref=5e-06
* NMOS master diode XB1 + mirror legs XB2/XB6. I_tail_n = i_ref*w_tail_n/w_bias_n,
* so w_bias_n = w_tail_n/2 seeds the NMOS tail at 2*i_ref.
.param w_bias_n=2.09e-05
* PMOS master diode XB3 + mirror leg XB4. Same 1:2 seed for the PMOS side.
.param w_bias_p=3.23e-06
* Constant-gm reference diodes XB5 (low) / XB7 (high). NARROWER than the master
* diodes at the same current => higher |Vgs| => the switch reference sits further
* from its rail, which is where the crossover has to be.
.param w_ref_n=8.36e-06
.param w_ref_p=1.29e-06
