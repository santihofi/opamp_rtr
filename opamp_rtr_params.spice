*=======================================================================================
* opamp_rtr_params.spice
* Seed / frozen design parameters for opamp_rtr.spice (PyOPUS designpar mirror)
*
* NOT included by opamp_rtr.spice during PyOPUS optimization (see note there).
* Standalone use: .include this file BEFORE opamp_rtr.spice in a manual deck.
* After optimization: paste the optimized values here to freeze the design.
*
* Values below are the winner of the 40-corner optimize_full_corner run
* (compute_results/optimize_full_corner.sqlite), carried over to the
* current-mode bias generator. Re-measured 2026-08-24 in ngspice-46 with the
* sg13g2 HV models, this design point gives:
*
*   RL=1e9  (unloaded)   gain 106.0 dB   idd  7.6 uA
*   RL=100k              gain  62.1 dB   idd 19.1 uA
*   RL=10k               gain  41.0 dB   idd  154 uA
*     all at the hardest corner: mos_fs, vdd 3.2, 100 C, vincm 3.1
*   tt/3.3/25/1.65, RL=10k:  gain 82.0 dB, tracking error 0.48 mV, idd 10.2 uA
*
* The load sets the second-stage gain: A2 = gm_out * (Rout || RL) and Rout is
* about 16 Mohm, so RL dominates for anything below a megohm. This is why the
* testbenches moved from RL=10k to RL=100k. At 10k the follower has to source
* (3.1-1.6)/10k = 150 uA at vincm=3.1, which is more than the whole 100 uA idd
* budget, and it does so with the output PMOS 100 mV from the rail when that
* device needs |Vdss| = 0.24 V to stay saturated.
*
* Step response (tb_opamp_rtr_pulse.spice, 100 mV step, RL=100k), 5 corners:
*   overshoot 5.35 to 14.30 %, 0.1 % settling 0.70 to 2.62 us,
*   closed-loop tracking error 0.25 to 1.11 mV
*=======================================================================================
* PMOS input pair
.param w_diff_p=6.5e-6
.param l_diff_p=2.93e-6
* NMOS input pair
.param w_diff_n=1.65e-5
.param l_diff_n=3.5e-6
* Input tails
.param w_tail_p=2.1e-5
.param w_tail_n=7.6e-6
* Shared L of every current-source / mirror device (bias generator included):
* the mirror ratios are pure width ratios only because L is common
.param l_bias=3.6e-6
* NMOS mirror load
.param w_load_n=4.12e-5
.param l_load_n=9.7e-6
* PMOS mirror load
.param w_load_p=1.94e-6
.param l_load_p=1.9e-6
* Output PMOS (was pinned at its 150u upper bound in the winning run)
.param w_out_p=1.2e-4
.param l_out_p=5.65e-7
* Output NMOS
.param w_out_n=7.97e-5
.param l_out_n=1.9e-6
* Monticelli floating NMOS + N-stack diodes
.param w_ab_n=3.47e-5
.param l_ab_n=2.55e-6
* Monticelli floating PMOS + P-stack diodes
.param w_ab_p=3.93e-6
.param l_ab_p=4.54e-6
* I_ab feed (PMOS XM15/XM17/XM23) and sink (NMOS XM16/XM20/XM24)
.param w_ab_src=1.47e-6
.param w_ab_snk=6.85e-7
* Miller caps
.param c_miller_p=3e-13
.param c_miller_n=3.3e-13
* Miller nulling resistors. Seeded at 1k, which is small against 1/gm_out
* (~5k at the output-stage bias), so the seed behaves like a plain Miller cap.
.param r_null_p=1e3
.param r_null_n=1e3
* Constant-gm current switches
.param w_sw_p=5.87e-5
.param w_sw_n=1e-5
* gm-switch mirrors: diode (1) and output (2) devices. Ratio w2/w1 sets how much
* the surviving pair is boosted (1x for weak inversion .. 3x for strong)
.param w_gmn1=4.1e-6
.param w_gmn2=1.45e-5
.param w_gmp1=8.5e-7
.param w_gmp2=1.1e-6
*=======================================================================================
* Current-mode bias generator (replaces the four distributed bias voltages).
* External reference current into the ibias pin. Every branch of the generator
* carries i_ref, and each biased device mirrors it by W ratio at l_bias.
.param i_ref=5.3e-7
* NMOS master diode XB1 + mirror legs XB2/XB6. I_tail_n = i_ref*w_tail_n/w_bias_n,
* so w_bias_n = w_tail_n/2 seeds the NMOS tail at 2*i_ref.
.param w_bias_n=3.46e-6
* PMOS master diode XB3 + mirror leg XB4. Same 1:2 seed for the PMOS side.
.param w_bias_p=9.87e-5
* Constant-gm reference diodes XB5 (low) / XB7 (high). NARROWER than the master
* diodes at the same current => higher |Vgs| => the switch reference sits further
* from its rail, which is where the crossover has to be.
.param w_ref_n=2.81e-5
.param w_ref_p=1.12e-5
