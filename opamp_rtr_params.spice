*=======================================================================================
* opamp_rtr_params.spice
* Seed / frozen design parameters for opamp_rtr.spice (PyOPUS designpar mirror)
*
* NOT included by opamp_rtr.spice during PyOPUS optimization (see note there).
* Standalone use: .include this file BEFORE opamp_rtr.spice in a manual deck.
* After optimization: paste the optimized values here to freeze the design.
*
* Seed for the low-tracking-error spec set. Starts from the 40-corner
* optimize_full_corner winner, moved to current-mode biasing, then corrected
* for three defects found by direct measurement on 2026-08-24 (ngspice-46,
* sg13g2 HV models, RL=100k):
*
*   1. The two input tails were 10x out of balance. Itail_P/i_ref = w_tail_p /
*      w_bias_p = 21.0/98.7 = 0.213 against Itail_N/i_ref = w_tail_n/w_bias_n =
*      7.6/3.46 = 2.20, so the PMOS pair carried 0.12 uA against 1.16 uA and the
*      amplifier was effectively NMOS-only. Now 0.57 uA each.
*   2. The constant-gm boost ratio w_gmn2/w_gmn1 was 3.54. In weak inversion gm
*      is proportional to I, so the survivor needs exactly the current the dead
*      pair gave up: ratio 1. At 3.54 the top of the range was over-boosted.
*   3. The two pairs had unequal gm per amp, 7.5 against 12.8 uS/uA, so no
*      steering ratio could flatten the crossover. w_diff_p widened to 11u.
*
* Together these cut the input gm spread from 5.11x to 2.13x over vincm. The
* Miller caps are then 3x their previous value, because above the crossover the
* PMOS pair stops driving out1_p and only one of the two Miller branches still
* compensates, which roughly halves the effective Cc.
*
* Measured worst case over the 12 corners the 60-corner sweep called hardest:
*   gain 63.07 dB   PM 62.5 deg   tracking error 0.796 mV   idd 19.06 uA
*   ugbw 453 kHz (lowest)   all at RL=100k
* Step response over 6 corners (tb_opamp_rtr_pulse.spice, 100 mV step):
*   overshoot 0.00 to 1.97 %, 1 percent settling 0.185 to 3.514 us,
*   closed-loop tracking error 0.219 to 0.775 mV
*
* For reference, before these three fixes the same corners gave PM 31.2 deg and
* 30.4 percent overshoot.
*
* The load matters more than any sizing: A2 = gm_out * (Rout || RL) with Rout
* about 16 Mohm, so at the hardest corner gain is 106.0 dB unloaded, 62.1 dB at
* RL=100k and 41.0 dB at RL=10k. At 10k the follower must also source
* (3.1-1.6)/10k = 150 uA at vincm=3.1, more than the whole 100 uA idd budget.
*=======================================================================================
* PMOS input pair
.param w_diff_p=16e-6
.param l_diff_p=4e-6
* NMOS input pair
.param w_diff_n=6.5e-6
.param l_diff_n=4e-6
* Input tails
.param w_tail_p=17e-6
.param w_tail_n=7e-6
* Shared L of every current-source / mirror device (bias generator included):
* the mirror ratios are pure width ratios only because L is common
.param l_bias=5e-6
* NMOS mirror load
.param w_load_n=1e-6
.param l_load_n=4e-6
* PMOS mirror load
.param w_load_p=6e-6
.param l_load_p=4e-6
* Output PMOS (was pinned at its 150u upper bound in the winning run)
.param w_out_p=11e-6
.param l_out_p=5e-7
* Output NMOS
.param w_out_n=5.5e-6
.param l_out_n=5e-7
* Monticelli floating NMOS + N-stack diodes
.param w_ab_n=8e-6
.param l_ab_n=1e-6
* Monticelli floating PMOS + P-stack diodes
.param w_ab_p=8e-6
.param l_ab_p=1e-6
* I_ab feed (PMOS XM15/XM17/XM23) and sink (NMOS XM16/XM20/XM24)
.param w_ab_src=5.5e-6
.param w_ab_snk=2.7e-6
* Miller caps
.param c_miller_p=3e-13
.param c_miller_n=3e-13
* Miller nulling resistors. Seeded at 1k, which is small against 1/gm_out
* (~5k at the output-stage bias), so the seed behaves like a plain Miller cap.
.param r_null_p=16
.param r_null_n=16
* Constant-gm current switches
.param w_sw_p=15e-6
.param w_sw_n=7e-6
* gm-switch mirrors: diode (1) and output (2) devices. Ratio w2/w1 sets how much
* the surviving pair is boosted (1x for weak inversion .. 3x for strong)
.param w_gmn=1.25e-6
.param w_gmp=11e-6
*=======================================================================================
* Current-mode bias generator (replaces the four distributed bias voltages).
* External reference current into the ibias pin. Every branch of the generator
* carries i_ref, and each biased device mirrors it by W ratio at l_bias.
.param i_ref=1.2e-6
* NMOS master diode XB1 + mirror legs XB2/XB6. I_tail_n = i_ref*w_tail_n/w_bias_n,
* so w_bias_n = w_tail_n/2 seeds the NMOS tail at 2*i_ref.
.param w_bias_n=5.5e-6
* PMOS master diode XB3 + mirror leg XB4. Same 1:2 seed for the PMOS side.
.param w_bias_p=11e-6
* Constant-gm reference diodes XB5 (low) / XB7 (high). NARROWER than the master
* diodes at the same current => higher |Vgs| => the switch reference sits further
* from its rail, which is where the crossover has to be.
.param w_ref_n=2.6e-6
.param w_ref_p=8e-6
