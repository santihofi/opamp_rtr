E1 inp net1 vdin GND 1
V1 net1 GND {vincm}
V2 vdd GND {vdd}
V4 vdin GND ac=1
* Single reference current into the ibias pin - stands in for bandgap+resistor
* (or a beta-multiplier). All four gate-bias rails are generated inside the
* opamp. Ib draws from vdd, so V2 still sees the total supply current.
Ib vdd nib {i_ref}
* mid-supply node: return for the application load only
Vmid nmid GND {vdd*0.5}
x1 vdd GND nib inp inn out opamp
* DC-closed / AC-open feedback: at DC the amp is a unity-gain follower, so the
* operating point is well-defined (out tracks vincm, offset bounded by loop).
* Above ~1e-19 Hz the loop is broken (Cfb shorts inn to GND), so ac and noise
* analyses see the open-loop amplifier: pm = phase margin of the follower loop.
* E1 gain is 1 so noise referred to v4 is true input-referred noise.
Rfb out inn 1e9
Cfb inn GND 1e9
* Application load = the diff-amp feedback network, returned to mid-supply.
* 100k not 10k: at vincm=3.1, vdd=3.2 a 10k return draws (3.1-1.6)/10k = 150 uA
* from the output PMOS while it sits 100 mV from the rail, which pushes it into
* triode (needs |Vdss|=0.24 V) and costs 65 dB of open-loop gain. See notes.
.param rl=100e3
RL out nmid {rl}
.param cl=5e-12
CL out GND {cl}

.GLOBAL GND
.end
