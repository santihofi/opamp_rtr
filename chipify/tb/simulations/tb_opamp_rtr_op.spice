** sch_path: /foss/designs/heichip/opamp_rtr/chipify/tb/tb_opamp_rtr_op.sch
**.subckt tb_opamp_rtr_op
E1 inp net1 VOL=' v(vdin)/2 '
E2 inn net1 VOL=' -v(vdin)/2 '
V1 net1 GND {{vincm}}
.save i(v1)
V2 vdd GND {{vdd}}
V4 GND vdin 0
.save i(v4)
x1 vdd inp GND inn net2 out opamp_rtr
I0 vdd net2 5u
**** begin user architecture code

.temp {{ temp }}
.param mc_ok = {{ sigma }}
.option SEED = {{ seed }}
.option method=gear

.control
op
quit
.endc

.lib cornerMOSlv.lib mos_{{ corner_mos }}
.lib cornerMOShv.lib mos_{{ corner_mos }}

**** end user architecture code
**.ends

* expanding   symbol:  heichip/opamp_rtr/chipify/sch/opamp_rtr.sym # of pins=6
** sym_path: /foss/designs/heichip/opamp_rtr/chipify/sch/opamp_rtr.sym
** sch_path: /foss/designs/heichip/opamp_rtr/chipify/sch/opamp_rtr.sch
.subckt opamp_rtr vdd inp vss inn ibias out
*.ipin inp
*.opin out
*.iopin vdd
*.ipin inn
*.ipin ibias
*.iopin vss
XXM6 out1_n inp ncmdiff_n vss sg13_hv_nmos w={w_diff_n} l={l_diff} ng={n_diff_n} m=1 mm_ok=1
XXM1 net1 inn ncmdiff_p vdd sg13_hv_pmos w={w_diff_p} l={l_diff} ng={n_diff_p} m=1 mm_ok=1
XXM2 ncmdiff_p inp out1_p vdd sg13_hv_pmos w={w_diff_p} l={l_diff} ng={n_diff_p} m=1 mm_ok=1
XXM3 ncmdiff_p vbias_p vdd vdd sg13_hv_pmos w={w_tail_p} l={l_bias} ng={n_tail_p} m=1 mm_ok=1
XXM4 vss net1 net1 vss sg13_hv_nmos w={w_load_n} l={l_load} ng={n_load_n} m=1 mm_ok=1
XXM5 out1_p net1 vss vss sg13_hv_nmos w={w_load_n} l={l_load} ng={n_load_n} m=1 mm_ok=1
XXM7 ncmdiff_n inn net2 vss sg13_hv_nmos w={w_diff_n} l={l_diff} ng={n_diff_n} m=1 mm_ok=1
XXM8 ncmdiff_n ibias vss vss sg13_hv_nmos w={w_tail_n} l={l_bias} ng={n_tail_n} m=1 mm_ok=1
XXM9 vdd net2 out1_n vdd sg13_hv_pmos w={w_load_p} l={l_load} ng={n_load_p} m=1 mm_ok=1
XXM10 net2 net2 vdd vdd sg13_hv_pmos w={w_load_p} l={l_load} ng={n_load_p} m=1 mm_ok=1
XXM25 nswa vref_p ncmdiff_p ncmdiff_p sg13_hv_pmos w={w_sw_p} l={l_sw} ng={n_sw_p} m=1 mm_ok=1
XXM26 nswa nswa vss vss sg13_hv_nmos w={w_gmn} l={l_bias} ng={n_gmn} m=1 mm_ok=1
XXM27 ncmdiff_n nswa vss vss sg13_hv_nmos w={w_gmn} l={l_bias} ng={n_gmn} m=1 mm_ok=1
XXM28 ncmdiff_n vref_n nswb vss sg13_hv_nmos w={w_sw_n} l={l_sw} ng={n_sw_n} m=1 mm_ok=1
XXM29 nswb nswb vdd vdd sg13_hv_pmos w={w_gmp} l={l_bias} ng={n_gmp} m=1 mm_ok=1
XXM30 ncmdiff_p nswb vdd vdd sg13_hv_pmos w={w_gmp} l={l_bias} ng={n_gmp} m=1 mm_ok=1
XXM13 out1_n nabn out1_p vss sg13_hv_nmos w={w_ab_n} l={l_ab} ng={n_ab_n} m=1 mm_ok=1
XXM14 out1_p nabp out1_n vdd sg13_hv_pmos w={w_ab_p} l={l_ab} ng={n_ab_p} m=1 mm_ok=1
XXM15 out1_n vbias_p vdd vdd sg13_hv_pmos w={w_ab_src} l={l_bias} ng={n_ab_src} m=1 mm_ok=1
XXM16 out1_p nab_ref vss vss sg13_hv_nmos w={w_ab_snk} l={l_bias} ng={n_ab_snk} m=1 mm_ok=1
XXM23 nab_ref vbias_p vdd vdd sg13_hv_pmos w={w_ab_src} l={l_bias} ng={n_ab_src} m=1 mm_ok=1
XXM24 nab_ref nab_ref vss vss sg13_hv_nmos w={w_ab_snk} l={l_bias} ng={n_ab_snk} m=1 mm_ok=1
XXM17 nabn vbias_p vdd vdd sg13_hv_pmos w={w_ab_src} l={l_bias} ng={n_ab_src} m=1 mm_ok=1
XXM18 nabn nabn net3 vss sg13_hv_nmos w={w_ab_n} l={l_ab} ng={n_ab_n} m=1 mm_ok=1
XXM19 net3 net3 vss vss sg13_hv_nmos w={w_ab_n} l={l_ab} ng={n_ab_n} m=1 mm_ok=1
XXM20 nabp nab_ref vss vss sg13_hv_nmos w={w_ab_snk} l={l_bias} ng={n_ab_snk} m=1 mm_ok=1
XXM21 nabp nabp net4 vdd sg13_hv_pmos w={w_ab_p} l={l_ab} ng={n_ab_p} m=1 mm_ok=1
XXM22 net4 net4 vdd vdd sg13_hv_pmos w={w_ab_p} l={l_ab} ng={n_ab_p} m=1 mm_ok=1
XXM11 out out1_n vdd vdd sg13_hv_pmos w={w_out_p} l={l_out} ng={n_out_p} m=1 mm_ok=1
XXM12 out out1_p vss vss sg13_hv_nmos w={w_out_n} l={l_out} ng={n_out_n} m=1 mm_ok=1
R1 out net5 {r_null}
C1 net5 out1_n {c_null}
R2 out net6 {r_null}
C2 net6 out1_p {c_null}
XXB1 ibias ibias vss vss sg13_hv_nmos w={w_bias_n} l={l_bias} ng={n_bias_n} m=1 mm_ok=1
XXB2 vbias_p ibias vss vss sg13_hv_nmos w={w_bias_n} l={l_bias} ng={n_bias_n} m=1 mm_ok=1
XXB5 vref_n vref_n vss vss sg13_hv_nmos w={w_ref_n} l={l_bias} ng={n_ref_n} m=1 mm_ok=1
XXB6 vref_p ibias vss vss sg13_hv_nmos w={w_bias_n} l={l_bias} ng={n_bias_n} m=1 mm_ok=1
XXB3 vbias_p vbias_p vdd vdd sg13_hv_pmos w={w_bias_p} l={l_bias} ng={n_bias_p} m=1 mm_ok=1
XXB4 vref_n vbias_p vdd vdd sg13_hv_pmos w={w_bias_p} l={l_bias} ng={n_bias_p} m=1 mm_ok=1
XXB7 vref_p vref_p vdd vdd sg13_hv_pmos w={w_ref_p} l={l_bias} ng={n_ref_p} m=1 mm_ok=1
**** begin user architecture code

*bias network
.param l_bias=2u
.param w_bias_p=10u
.param w_bias_n=5u
.param w_ref_n=5u
.param w_ref_p=10u
*first stage
.param l_diff=1u
.param l_load=4u

.param w_diff_n=5u
.param n_diff_n=4

.param w_diff_p=10u
.param n_diff_p=4

.param w_load_n=5u
.param n_load_n=4

.param w_load_p=10u
.param n_load_p=4

.param w_tail_n=5u
.param n_tail_n=4

.param w_tail_p=10u
.param n_tail_p=4

.param l_sw=1u
.param w_sw_p=10u
.param n_sw_p=4

.param w_sw_n=5u
.param n_sw_n=4

.param w_gmn=5u
.param n_gmn=4

.param w_gmp=10u
.param n_gmp=4

*output control circuit
.param w_ab_src=10u
.param n_ab_src=4
.param w_ab_snk=5u
.param n_ab_snk=4

.param w_ab_n=5u
.param n_ab_n=4
.param w_ab_p=10u
.param n_ab_p=4

.param l_ab=1u

.param w_out_p=20u
.param n_out_p=4
.param w_out_n=10u
.param n_out_n=4

.param r_null=2k
.param c_null=200f

**** end user architecture code
.ends

.GLOBAL GND
.end
