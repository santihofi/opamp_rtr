** sch_path: /foss/designs/heichip/opamp_rtr/chipify/sch/opamp_rtr.sch
**.subckt opamp_rtr vdd inp vss inn ibias out
*.ipin inp
*.opin out
*.iopin vdd
*.ipin inn
*.ipin ibias
*.iopin vss
XXM6 out1_n inp ncmdiff_n vss sg13_hv_nmos w={w_diff_n} l={l_diff} ng={n_diff_n} m=1 mm_ok=1
XXM1 net1 inn ncmdiff_p vdd sg13_hv_pmos w={w_diff_p} l={l_diff} ng={n_diff_p} m=1 mm_ok=1
XXM2 ncmdiff_p inp out1_p vdd sg13_hv_pmos w={w_diff_p} l={l_diff} ng={n_diff_p} m=1 mm_ok=1
XXM3 ncmdiff_p vbias_p vdd vdd sg13_hv_pmos w={w_tail_p} l={l_bias} ng={n_tail_p} m=1 mm_ok=1
XXM4 vss net1 net1 vss sg13_hv_nmos w={w_load_n} l={l_load} ng={n_load_n} m=1 mm_ok=1
XXM5 out1_p net1 vss vss sg13_hv_nmos w={w_load_n} l={l_load} ng={n_load_n} m=1 mm_ok=1
XXM7 ncmdiff_n inn net2 vss sg13_hv_nmos w={w_diff_n} l={l_diff} ng={n_diff_n} m=1 mm_ok=1
XXM8 ncmdiff_n ibias vss vss sg13_hv_nmos w={w_tail_n} l={l_bias} ng={n_tail_n} m=1 mm_ok=1
XXM9 vdd net2 out1_n vdd sg13_hv_pmos w={w_load_p} l={l_load} ng={n_load_p} m=1 mm_ok=1
XXM10 net2 net2 vdd vdd sg13_hv_pmos w={w_load_p} l={l_load} ng={n_load_p} m=1 mm_ok=1
XXM25 nswa vref_p ncmdiff_p ncmdiff_p sg13_hv_pmos w={w_sw_p} l={l_sw} ng={n_sw_p} m=1 mm_ok=1
XXM26 nswa nswa vss vss sg13_hv_nmos w={w_gmn} l={l_bias} ng={n_gmn} m=1 mm_ok=1
XXM27 ncmdiff_n nswa vss vss sg13_hv_nmos w={w_gmn} l={l_bias} ng={n_gmn} m=1 mm_ok=1
XXM28 ncmdiff_n vref_n nswb vss sg13_hv_nmos w={w_sw_n} l={l_sw} ng={n_sw_n} m=1 mm_ok=1
XXM29 nswb nswb vdd vdd sg13_hv_pmos w={w_gmp} l={l_bias} ng={n_gmp} m=1 mm_ok=1
XXM30 ncmdiff_p nswb vdd vdd sg13_hv_pmos w={w_gmp} l={l_bias} ng={n_gmp} m=1 mm_ok=1
XXM13 out1_n nabn out1_p vss sg13_hv_nmos w={w_ab_n} l={l_ab} ng={n_ab_n} m=1 mm_ok=1
XXM14 out1_p nabp out1_n vdd sg13_hv_pmos w={w_ab_p} l={l_ab} ng={n_ab_p} m=1 mm_ok=1
XXM15 out1_n vbias_p vdd vdd sg13_hv_pmos w={w_ab_src} l={l_bias} ng={n_ab_src} m=1 mm_ok=1
XXM16 out1_p nab_ref vss vss sg13_hv_nmos w={w_ab_snk} l={l_bias} ng={n_ab_snk} m=1 mm_ok=1
XXM23 nab_ref vbias_p vdd vdd sg13_hv_pmos w={w_ab_src} l={l_bias} ng={n_ab_src} m=1 mm_ok=1
XXM24 nab_ref nab_ref vss vss sg13_hv_nmos w={w_ab_snk} l={l_bias} ng={n_ab_snk} m=1 mm_ok=1
XXM17 nabn vbias_p vdd vdd sg13_hv_pmos w={w_ab_src} l={l_bias} ng={n_ab_src} m=1 mm_ok=1
XXM18 nabn nabn net3 vss sg13_hv_nmos w={w_ab_n} l={l_ab} ng={n_ab_n} m=1 mm_ok=1
XXM19 net3 net3 vss vss sg13_hv_nmos w={w_ab_n} l={l_ab} ng={n_ab_n} m=1 mm_ok=1
XXM20 nabp nab_ref vss vss sg13_hv_nmos w={w_ab_snk} l={l_bias} ng={n_ab_snk} m=1 mm_ok=1
XXM21 nabp nabp net4 vdd sg13_hv_pmos w={w_ab_p} l={l_ab} ng={n_ab_p} m=1 mm_ok=1
XXM22 net4 net4 vdd vdd sg13_hv_pmos w={w_ab_p} l={l_ab} ng={n_ab_p} m=1 mm_ok=1
XXM11 out out1_n vdd vdd sg13_hv_pmos w={w_out_p} l={l_out} ng={n_out_p} m=1 mm_ok=1
XXM12 out out1_p vss vss sg13_hv_nmos w={w_out_n} l={l_out} ng={n_out_n} m=1 mm_ok=1
XXB1 ibias ibias vss vss sg13_hv_nmos w={w_bias_n} l={l_bias} ng={n_bias_n} m=1 mm_ok=1
XXB2 vbias_p ibias vss vss sg13_hv_nmos w={w_bias_n} l={l_bias} ng={n_bias_n} m=1 mm_ok=1
XXB5 vref_n vref_n vss vss sg13_hv_nmos w={w_ref_n} l={l_bias} ng={n_ref_n} m=1 mm_ok=1
XXB6 vref_p ibias vss vss sg13_hv_nmos w={w_bias_n} l={l_bias} ng={n_bias_n} m=1 mm_ok=1
XXB3 vbias_p vbias_p vdd vdd sg13_hv_pmos w={w_bias_p} l={l_bias} ng={n_bias_p} m=1 mm_ok=1
XXB4 vref_n vbias_p vdd vdd sg13_hv_pmos w={w_bias_p} l={l_bias} ng={n_bias_p} m=1 mm_ok=1
XXB7 vref_p vref_p vdd vdd sg13_hv_pmos w={w_ref_p} l={l_bias} ng={n_ref_p} m=1 mm_ok=1
XC3 out net5 cap_cmomf w=13.5e-6 l=21e-6 mmin=1 mmax=4 subblock=0 m=1 mm_ok=1
XC2 out net6 cap_cmomf w=13.5e-6 l=21e-6 mmin=1 mmax=4 subblock=0 m=1 mm_ok=1
XR4 net5 out1_n vss rhigh w=1e-6 l=36e-6 m=1 b=0 mm_ok=1
XR2 net6 out1_p vss rhigh w=1e-6 l=36e-6 m=1 b=0 mm_ok=1
XDUMMY1 ncmdiff_n ncmdiff_n ncmdiff_n vss sg13_hv_nmos w=5u l=0.45u ng=4 m=1 mm_ok=1
XDUMMY2 ncmdiff_n ncmdiff_n ncmdiff_n vss sg13_hv_nmos w=5u l=0.45u ng=2 m=1 mm_ok=1
XDUMMY3 vss vss vss vss sg13_hv_nmos w=7.5u l=0.45u ng=6 m=1 mm_ok=1
XDUMMY4 vss vss vss vss sg13_hv_nmos w=10u l=0.45u ng=4 m=1 mm_ok=1
XDUMMY5 out1_p out1_p out1_p vss sg13_hv_nmos w=5u l=1u ng=2 m=1 mm_ok=1
XDUMMY6 vdd vdd vdd vdd sg13_hv_pmos w=22.5u l=0.4u ng=6 m=1 mm_ok=1
XDUMMY7 nswa nswa nswa vdd sg13_hv_pmos w=15u l=0.4u ng=2 m=1 mm_ok=1
XDUMMY8 vdd vdd vdd vdd sg13_hv_pmos w=15u l=0.4u ng=4 m=1 mm_ok=1
XDUMMY9 vdd vdd vdd vdd sg13_hv_pmos w=37.5u l=0.4u ng=5 m=1 mm_ok=1
XDUMMY10 out1_n out1_n out1_n vdd sg13_hv_pmos w=15u l=0.4u ng=2 m=1 mm_ok=1
XDUMMY11 vss vss vss vss sg13_hv_nmos w=5u l=0.45u ng=2 m=1 mm_ok=1
XR3 vss vss vss rhigh w=1e-6 l=18e-6 m=1 b=0 mm_ok=1
**** begin user architecture code

*bias network
.param l_bias=4u
.param w_bias_p=15u
.param n_bias_p=4
.param w_bias_n=5u
.param n_bias_n=5
.param w_ref_n=5u
.param n_ref_n=4
.param w_ref_p=15u
.param n_ref_p=4
*first stage
.param l_diff=2u
.param l_load=4u

.param w_diff_n=5u
.param n_diff_n=4

.param w_diff_p=15u
.param n_diff_p=4

.param w_load_n=5u
.param n_load_n=4

.param w_load_p=15u
.param n_load_p=4

.param w_tail_n=5u
.param n_tail_n=4

.param w_tail_p=15u
.param n_tail_p=4

.param l_sw=1u
.param w_sw_p=15u
.param n_sw_p=4

.param w_sw_n=5u
.param n_sw_n=4

.param w_gmn=5u
.param n_gmn=4

.param w_gmp=15u
.param n_gmp=4

*output control circuit
.param w_ab_src=15u
.param n_ab_src=4
.param w_ab_snk=5u
.param n_ab_snk=4

.param w_ab_n=5u
.param n_ab_n=4
.param w_ab_p=15u
.param n_ab_p=4

.param l_ab=1u

.param w_out_p=60u
.param n_out_p=4
.param w_out_n=20u
.param n_out_n=4
.param l_out=1u

.param r_null=50k
.param c_null=500f

**** end user architecture code
**.ends
.end
